* NGSPICE file created from top.ext - technology: sky130A

* Black-box entry subcircuit for sky130_ef_sc_hd__decap_12 abstract view
.subckt sky130_ef_sc_hd__decap_12 VPWR VGND VPB VNB
.ends

* Black-box entry subcircuit for sky130_fd_sc_hd__fill_2 abstract view
.subckt sky130_fd_sc_hd__fill_2 VGND VNB VPB VPWR
.ends

* Black-box entry subcircuit for sky130_fd_sc_hd__tapvpwrvgnd_1 abstract view
.subckt sky130_fd_sc_hd__tapvpwrvgnd_1 VGND VPWR
.ends

* Black-box entry subcircuit for sky130_fd_sc_hd__decap_8 abstract view
.subckt sky130_fd_sc_hd__decap_8 VGND VNB VPB VPWR
.ends

* Black-box entry subcircuit for sky130_fd_sc_hd__decap_3 abstract view
.subckt sky130_fd_sc_hd__decap_3 VGND VNB VPB VPWR
.ends

* Black-box entry subcircuit for sky130_fd_sc_hd__fill_1 abstract view
.subckt sky130_fd_sc_hd__fill_1 VGND VNB VPB VPWR
.ends

* Black-box entry subcircuit for sky130_fd_sc_hd__o21a_1 abstract view
.subckt sky130_fd_sc_hd__o21a_1 A1 A2 B1 VGND VNB VPB VPWR X
.ends

* Black-box entry subcircuit for sky130_fd_sc_hd__nand3_1 abstract view
.subckt sky130_fd_sc_hd__nand3_1 A B C VGND VNB VPB VPWR Y
.ends

* Black-box entry subcircuit for sky130_fd_sc_hd__clkbuf_4 abstract view
.subckt sky130_fd_sc_hd__clkbuf_4 A VGND VNB VPB VPWR X
.ends

* Black-box entry subcircuit for sky130_fd_sc_hd__dfxtp_1 abstract view
.subckt sky130_fd_sc_hd__dfxtp_1 CLK D VGND VNB VPB VPWR Q
.ends

* Black-box entry subcircuit for sky130_fd_sc_hd__decap_6 abstract view
.subckt sky130_fd_sc_hd__decap_6 VGND VNB VPB VPWR
.ends

* Black-box entry subcircuit for sky130_fd_sc_hd__decap_4 abstract view
.subckt sky130_fd_sc_hd__decap_4 VGND VNB VPB VPWR
.ends

* Black-box entry subcircuit for sky130_fd_sc_hd__and2_1 abstract view
.subckt sky130_fd_sc_hd__and2_1 A B VGND VNB VPB VPWR X
.ends

* Black-box entry subcircuit for sky130_fd_sc_hd__and2b_1 abstract view
.subckt sky130_fd_sc_hd__and2b_1 A_N B VGND VNB VPB VPWR X
.ends

* Black-box entry subcircuit for sky130_fd_sc_hd__nor2_1 abstract view
.subckt sky130_fd_sc_hd__nor2_1 A B VGND VNB VPB VPWR Y
.ends

* Black-box entry subcircuit for sky130_fd_sc_hd__xor2_1 abstract view
.subckt sky130_fd_sc_hd__xor2_1 A B VGND VNB VPB VPWR X
.ends

* Black-box entry subcircuit for sky130_fd_sc_hd__a21o_1 abstract view
.subckt sky130_fd_sc_hd__a21o_1 A1 A2 B1 VGND VNB VPB VPWR X
.ends

* Black-box entry subcircuit for sky130_fd_sc_hd__o221a_1 abstract view
.subckt sky130_fd_sc_hd__o221a_1 A1 A2 B1 B2 C1 VGND VNB VPB VPWR X
.ends

* Black-box entry subcircuit for sky130_fd_sc_hd__nand2_1 abstract view
.subckt sky130_fd_sc_hd__nand2_1 A B VGND VNB VPB VPWR Y
.ends

* Black-box entry subcircuit for sky130_fd_sc_hd__mux2_1 abstract view
.subckt sky130_fd_sc_hd__mux2_1 A0 A1 S VGND VNB VPB VPWR X
.ends

* Black-box entry subcircuit for sky130_fd_sc_hd__o21ai_1 abstract view
.subckt sky130_fd_sc_hd__o21ai_1 A1 A2 B1 VGND VNB VPB VPWR Y
.ends

* Black-box entry subcircuit for sky130_fd_sc_hd__conb_1 abstract view
.subckt sky130_fd_sc_hd__conb_1 VGND VNB VPB VPWR HI LO
.ends

* Black-box entry subcircuit for sky130_fd_sc_hd__a22o_1 abstract view
.subckt sky130_fd_sc_hd__a22o_1 A1 A2 B1 B2 VGND VNB VPB VPWR X
.ends

* Black-box entry subcircuit for sky130_fd_sc_hd__dlygate4sd3_1 abstract view
.subckt sky130_fd_sc_hd__dlygate4sd3_1 A VGND VNB VPB VPWR X
.ends

* Black-box entry subcircuit for sky130_fd_sc_hd__a21bo_1 abstract view
.subckt sky130_fd_sc_hd__a21bo_1 A1 A2 B1_N VGND VNB VPB VPWR X
.ends

* Black-box entry subcircuit for sky130_fd_sc_hd__or3b_2 abstract view
.subckt sky130_fd_sc_hd__or3b_2 A B C_N VGND VNB VPB VPWR X
.ends

* Black-box entry subcircuit for sky130_fd_sc_hd__buf_2 abstract view
.subckt sky130_fd_sc_hd__buf_2 A VGND VNB VPB VPWR X
.ends

* Black-box entry subcircuit for sky130_fd_sc_hd__clkbuf_16 abstract view
.subckt sky130_fd_sc_hd__clkbuf_16 A VGND VNB VPB VPWR X
.ends

* Black-box entry subcircuit for sky130_fd_sc_hd__dlymetal6s2s_1 abstract view
.subckt sky130_fd_sc_hd__dlymetal6s2s_1 A VGND VNB VPB VPWR X
.ends

* Black-box entry subcircuit for sky130_fd_sc_hd__and3_1 abstract view
.subckt sky130_fd_sc_hd__and3_1 A B C VGND VNB VPB VPWR X
.ends

* Black-box entry subcircuit for sky130_fd_sc_hd__xnor2_1 abstract view
.subckt sky130_fd_sc_hd__xnor2_1 A B VGND VNB VPB VPWR Y
.ends

* Black-box entry subcircuit for sky130_fd_sc_hd__or2_1 abstract view
.subckt sky130_fd_sc_hd__or2_1 A B VGND VNB VPB VPWR X
.ends

* Black-box entry subcircuit for sky130_fd_sc_hd__a21oi_1 abstract view
.subckt sky130_fd_sc_hd__a21oi_1 A1 A2 B1 VGND VNB VPB VPWR Y
.ends

* Black-box entry subcircuit for sky130_fd_sc_hd__or2_4 abstract view
.subckt sky130_fd_sc_hd__or2_4 A B VGND VNB VPB VPWR X
.ends

* Black-box entry subcircuit for sky130_fd_sc_hd__o21ai_2 abstract view
.subckt sky130_fd_sc_hd__o21ai_2 A1 A2 B1 VGND VNB VPB VPWR Y
.ends

* Black-box entry subcircuit for sky130_fd_sc_hd__o211a_1 abstract view
.subckt sky130_fd_sc_hd__o211a_1 A1 A2 B1 C1 VGND VNB VPB VPWR X
.ends

* Black-box entry subcircuit for sky130_fd_sc_hd__or3_1 abstract view
.subckt sky130_fd_sc_hd__or3_1 A B C VGND VNB VPB VPWR X
.ends

* Black-box entry subcircuit for sky130_fd_sc_hd__dlygate4sd1_1 abstract view
.subckt sky130_fd_sc_hd__dlygate4sd1_1 A VGND VNB VPB VPWR X
.ends

* Black-box entry subcircuit for sky130_fd_sc_hd__o21bai_1 abstract view
.subckt sky130_fd_sc_hd__o21bai_1 A1 A2 B1_N VGND VNB VPB VPWR Y
.ends

* Black-box entry subcircuit for sky130_fd_sc_hd__and2_4 abstract view
.subckt sky130_fd_sc_hd__and2_4 A B VGND VNB VPB VPWR X
.ends

* Black-box entry subcircuit for sky130_fd_sc_hd__a21oi_2 abstract view
.subckt sky130_fd_sc_hd__a21oi_2 A1 A2 B1 VGND VNB VPB VPWR Y
.ends

* Black-box entry subcircuit for sky130_fd_sc_hd__and4b_1 abstract view
.subckt sky130_fd_sc_hd__and4b_1 A_N B C D VGND VNB VPB VPWR X
.ends

* Black-box entry subcircuit for sky130_fd_sc_hd__a31o_1 abstract view
.subckt sky130_fd_sc_hd__a31o_1 A1 A2 A3 B1 VGND VNB VPB VPWR X
.ends

* Black-box entry subcircuit for sky130_fd_sc_hd__a211o_1 abstract view
.subckt sky130_fd_sc_hd__a211o_1 A1 A2 B1 C1 VGND VNB VPB VPWR X
.ends

* Black-box entry subcircuit for sky130_fd_sc_hd__a211oi_2 abstract view
.subckt sky130_fd_sc_hd__a211oi_2 A1 A2 B1 C1 VGND VNB VPB VPWR Y
.ends

* Black-box entry subcircuit for sky130_fd_sc_hd__nand3_2 abstract view
.subckt sky130_fd_sc_hd__nand3_2 A B C VGND VNB VPB VPWR Y
.ends

* Black-box entry subcircuit for sky130_fd_sc_hd__clkbuf_2 abstract view
.subckt sky130_fd_sc_hd__clkbuf_2 A VGND VNB VPB VPWR X
.ends

* Black-box entry subcircuit for sky130_fd_sc_hd__inv_2 abstract view
.subckt sky130_fd_sc_hd__inv_2 A VGND VNB VPB VPWR Y
.ends

* Black-box entry subcircuit for sky130_fd_sc_hd__o2bb2a_1 abstract view
.subckt sky130_fd_sc_hd__o2bb2a_1 A1_N A2_N B1 B2 VGND VNB VPB VPWR X
.ends

* Black-box entry subcircuit for sky130_fd_sc_hd__o41a_1 abstract view
.subckt sky130_fd_sc_hd__o41a_1 A1 A2 A3 A4 B1 VGND VNB VPB VPWR X
.ends

* Black-box entry subcircuit for sky130_fd_sc_hd__clkinv_4 abstract view
.subckt sky130_fd_sc_hd__clkinv_4 A VGND VNB VPB VPWR Y
.ends

* Black-box entry subcircuit for sky130_fd_sc_hd__nor3_1 abstract view
.subckt sky130_fd_sc_hd__nor3_1 A B C VGND VNB VPB VPWR Y
.ends

* Black-box entry subcircuit for sky130_fd_sc_hd__a211oi_4 abstract view
.subckt sky130_fd_sc_hd__a211oi_4 A1 A2 B1 C1 VGND VNB VPB VPWR Y
.ends

* Black-box entry subcircuit for sky130_fd_sc_hd__a22oi_2 abstract view
.subckt sky130_fd_sc_hd__a22oi_2 A1 A2 B1 B2 VGND VNB VPB VPWR Y
.ends

* Black-box entry subcircuit for sky130_fd_sc_hd__buf_6 abstract view
.subckt sky130_fd_sc_hd__buf_6 A VGND VNB VPB VPWR X
.ends

* Black-box entry subcircuit for sky130_fd_sc_hd__a311o_1 abstract view
.subckt sky130_fd_sc_hd__a311o_1 A1 A2 A3 B1 C1 VGND VNB VPB VPWR X
.ends

* Black-box entry subcircuit for sky130_fd_sc_hd__clkbuf_8 abstract view
.subckt sky130_fd_sc_hd__clkbuf_8 A VGND VNB VPB VPWR X
.ends

* Black-box entry subcircuit for sky130_fd_sc_hd__and4_1 abstract view
.subckt sky130_fd_sc_hd__and4_1 A B C D VGND VNB VPB VPWR X
.ends

* Black-box entry subcircuit for sky130_fd_sc_hd__dfxtp_2 abstract view
.subckt sky130_fd_sc_hd__dfxtp_2 CLK D VGND VNB VPB VPWR Q
.ends

* Black-box entry subcircuit for sky130_fd_sc_hd__and3_4 abstract view
.subckt sky130_fd_sc_hd__and3_4 A B C VGND VNB VPB VPWR X
.ends

* Black-box entry subcircuit for sky130_fd_sc_hd__nand2b_1 abstract view
.subckt sky130_fd_sc_hd__nand2b_1 A_N B VGND VNB VPB VPWR Y
.ends

* Black-box entry subcircuit for sky130_fd_sc_hd__a2bb2o_4 abstract view
.subckt sky130_fd_sc_hd__a2bb2o_4 A1_N A2_N B1 B2 VGND VNB VPB VPWR X
.ends

* Black-box entry subcircuit for sky130_fd_sc_hd__inv_6 abstract view
.subckt sky130_fd_sc_hd__inv_6 A VGND VNB VPB VPWR Y
.ends

* Black-box entry subcircuit for sky130_fd_sc_hd__buf_4 abstract view
.subckt sky130_fd_sc_hd__buf_4 A VGND VNB VPB VPWR X
.ends

* Black-box entry subcircuit for sky130_fd_sc_hd__bufinv_16 abstract view
.subckt sky130_fd_sc_hd__bufinv_16 A VGND VNB VPB VPWR Y
.ends

* Black-box entry subcircuit for sky130_fd_sc_hd__or3b_4 abstract view
.subckt sky130_fd_sc_hd__or3b_4 A B C_N VGND VNB VPB VPWR X
.ends

* Black-box entry subcircuit for sky130_fd_sc_hd__nand3b_1 abstract view
.subckt sky130_fd_sc_hd__nand3b_1 A_N B C VGND VNB VPB VPWR Y
.ends

* Black-box entry subcircuit for sky130_fd_sc_hd__dfxtp_4 abstract view
.subckt sky130_fd_sc_hd__dfxtp_4 CLK D VGND VNB VPB VPWR Q
.ends

* Black-box entry subcircuit for sky130_fd_sc_hd__xnor2_2 abstract view
.subckt sky130_fd_sc_hd__xnor2_2 A B VGND VNB VPB VPWR Y
.ends

* Black-box entry subcircuit for sky130_fd_sc_hd__clkinvlp_4 abstract view
.subckt sky130_fd_sc_hd__clkinvlp_4 A VGND VNB VPB VPWR Y
.ends

* Black-box entry subcircuit for sky130_fd_sc_hd__or3_4 abstract view
.subckt sky130_fd_sc_hd__or3_4 A B C VGND VNB VPB VPWR X
.ends

* Black-box entry subcircuit for sky130_fd_sc_hd__nand4_1 abstract view
.subckt sky130_fd_sc_hd__nand4_1 A B C D VGND VNB VPB VPWR Y
.ends

* Black-box entry subcircuit for sky130_fd_sc_hd__o211ai_2 abstract view
.subckt sky130_fd_sc_hd__o211ai_2 A1 A2 B1 C1 VGND VNB VPB VPWR Y
.ends

* Black-box entry subcircuit for sky130_fd_sc_hd__a211oi_1 abstract view
.subckt sky130_fd_sc_hd__a211oi_1 A1 A2 B1 C1 VGND VNB VPB VPWR Y
.ends

* Black-box entry subcircuit for sky130_fd_sc_hd__buf_12 abstract view
.subckt sky130_fd_sc_hd__buf_12 A VGND VNB VPB VPWR X
.ends

* Black-box entry subcircuit for sky130_fd_sc_hd__buf_1 abstract view
.subckt sky130_fd_sc_hd__buf_1 A VGND VNB VPB VPWR X
.ends

* Black-box entry subcircuit for sky130_fd_sc_hd__xnor2_4 abstract view
.subckt sky130_fd_sc_hd__xnor2_4 A B VGND VNB VPB VPWR Y
.ends

* Black-box entry subcircuit for sky130_fd_sc_hd__or4_1 abstract view
.subckt sky130_fd_sc_hd__or4_1 A B C D VGND VNB VPB VPWR X
.ends

* Black-box entry subcircuit for sky130_fd_sc_hd__a21boi_1 abstract view
.subckt sky130_fd_sc_hd__a21boi_1 A1 A2 B1_N VGND VNB VPB VPWR Y
.ends

* Black-box entry subcircuit for sky130_fd_sc_hd__clkbuf_1 abstract view
.subckt sky130_fd_sc_hd__clkbuf_1 A VGND VNB VPB VPWR X
.ends

* Black-box entry subcircuit for sky130_fd_sc_hd__o211a_4 abstract view
.subckt sky130_fd_sc_hd__o211a_4 A1 A2 B1 C1 VGND VNB VPB VPWR X
.ends

* Black-box entry subcircuit for sky130_fd_sc_hd__nand2_4 abstract view
.subckt sky130_fd_sc_hd__nand2_4 A B VGND VNB VPB VPWR Y
.ends

* Black-box entry subcircuit for sky130_fd_sc_hd__buf_8 abstract view
.subckt sky130_fd_sc_hd__buf_8 A VGND VNB VPB VPWR X
.ends

* Black-box entry subcircuit for sky130_fd_sc_hd__or4b_1 abstract view
.subckt sky130_fd_sc_hd__or4b_1 A B C D_N VGND VNB VPB VPWR X
.ends

* Black-box entry subcircuit for sky130_fd_sc_hd__nor2_2 abstract view
.subckt sky130_fd_sc_hd__nor2_2 A B VGND VNB VPB VPWR Y
.ends

* Black-box entry subcircuit for sky130_fd_sc_hd__nand2_2 abstract view
.subckt sky130_fd_sc_hd__nand2_2 A B VGND VNB VPB VPWR Y
.ends

* Black-box entry subcircuit for sky130_fd_sc_hd__a221o_1 abstract view
.subckt sky130_fd_sc_hd__a221o_1 A1 A2 B1 B2 C1 VGND VNB VPB VPWR X
.ends

* Black-box entry subcircuit for sky130_fd_sc_hd__xor2_2 abstract view
.subckt sky130_fd_sc_hd__xor2_2 A B VGND VNB VPB VPWR X
.ends

* Black-box entry subcircuit for sky130_fd_sc_hd__or3b_1 abstract view
.subckt sky130_fd_sc_hd__or3b_1 A B C_N VGND VNB VPB VPWR X
.ends

* Black-box entry subcircuit for sky130_fd_sc_hd__o21ba_1 abstract view
.subckt sky130_fd_sc_hd__o21ba_1 A1 A2 B1_N VGND VNB VPB VPWR X
.ends

* Black-box entry subcircuit for sky130_fd_sc_hd__a22oi_1 abstract view
.subckt sky130_fd_sc_hd__a22oi_1 A1 A2 B1 B2 VGND VNB VPB VPWR Y
.ends

* Black-box entry subcircuit for sky130_fd_sc_hd__or4_4 abstract view
.subckt sky130_fd_sc_hd__or4_4 A B C D VGND VNB VPB VPWR X
.ends

* Black-box entry subcircuit for sky130_fd_sc_hd__nand2b_4 abstract view
.subckt sky130_fd_sc_hd__nand2b_4 A_N B VGND VNB VPB VPWR Y
.ends

* Black-box entry subcircuit for sky130_fd_sc_hd__and2b_4 abstract view
.subckt sky130_fd_sc_hd__and2b_4 A_N B VGND VNB VPB VPWR X
.ends

* Black-box entry subcircuit for sky130_fd_sc_hd__nor2_4 abstract view
.subckt sky130_fd_sc_hd__nor2_4 A B VGND VNB VPB VPWR Y
.ends

* Black-box entry subcircuit for sky130_fd_sc_hd__a2bb2o_1 abstract view
.subckt sky130_fd_sc_hd__a2bb2o_1 A1_N A2_N B1 B2 VGND VNB VPB VPWR X
.ends

* Black-box entry subcircuit for sky130_fd_sc_hd__o21bai_2 abstract view
.subckt sky130_fd_sc_hd__o21bai_2 A1 A2 B1_N VGND VNB VPB VPWR Y
.ends

* Black-box entry subcircuit for sky130_fd_sc_hd__o31a_1 abstract view
.subckt sky130_fd_sc_hd__o31a_1 A1 A2 A3 B1 VGND VNB VPB VPWR X
.ends

* Black-box entry subcircuit for sky130_fd_sc_hd__nor4_1 abstract view
.subckt sky130_fd_sc_hd__nor4_1 A B C D VGND VNB VPB VPWR Y
.ends

* Black-box entry subcircuit for sky130_fd_sc_hd__o41ai_2 abstract view
.subckt sky130_fd_sc_hd__o41ai_2 A1 A2 A3 A4 B1 VGND VNB VPB VPWR Y
.ends

* Black-box entry subcircuit for sky130_fd_sc_hd__o21ba_4 abstract view
.subckt sky130_fd_sc_hd__o21ba_4 A1 A2 B1_N VGND VNB VPB VPWR X
.ends

* Black-box entry subcircuit for sky130_fd_sc_hd__diode_2 abstract view
.subckt sky130_fd_sc_hd__diode_2 DIODE VGND VNB VPB VPWR
.ends

* Black-box entry subcircuit for sky130_fd_sc_hd__dlymetal6s4s_1 abstract view
.subckt sky130_fd_sc_hd__dlymetal6s4s_1 A VGND VNB VPB VPWR X
.ends

* Black-box entry subcircuit for sky130_fd_sc_hd__or4bb_4 abstract view
.subckt sky130_fd_sc_hd__or4bb_4 A B C_N D_N VGND VNB VPB VPWR X
.ends

* Black-box entry subcircuit for sky130_fd_sc_hd__o31ai_1 abstract view
.subckt sky130_fd_sc_hd__o31ai_1 A1 A2 A3 B1 VGND VNB VPB VPWR Y
.ends

* Black-box entry subcircuit for sky130_fd_sc_hd__o21ai_4 abstract view
.subckt sky130_fd_sc_hd__o21ai_4 A1 A2 B1 VGND VNB VPB VPWR Y
.ends

.subckt top VGND VPWR addr[0] addr[1] addr[2] addr[3] addr[4] addr[5] addr[6] addr[7]
+ clk rdata[0] rdata[10] rdata[11] rdata[12] rdata[13] rdata[14] rdata[15] rdata[16]
+ rdata[17] rdata[18] rdata[19] rdata[1] rdata[20] rdata[21] rdata[22] rdata[23] rdata[24]
+ rdata[25] rdata[26] rdata[27] rdata[28] rdata[29] rdata[2] rdata[30] rdata[31] rdata[3]
+ rdata[4] rdata[5] rdata[6] rdata[7] rdata[8] rdata[9] ready rst valid wdata[0] wdata[10]
+ wdata[11] wdata[12] wdata[13] wdata[14] wdata[15] wdata[16] wdata[17] wdata[18]
+ wdata[19] wdata[1] wdata[20] wdata[21] wdata[22] wdata[23] wdata[24] wdata[25] wdata[26]
+ wdata[27] wdata[28] wdata[29] wdata[2] wdata[30] wdata[31] wdata[3] wdata[4] wdata[5]
+ wdata[6] wdata[7] wdata[8] wdata[9] write
XFILLER_54_236 VPWR VGND VPWR VGND sky130_ef_sc_hd__decap_12
XFILLER_54_214 VGND VGND VPWR VPWR sky130_fd_sc_hd__fill_2
XTAP_TAPCELL_ROW_37_401 VGND VPWR sky130_fd_sc_hd__tapvpwrvgnd_1
XFILLER_36_19 VGND VGND VPWR VPWR sky130_fd_sc_hd__decap_8
XFILLER_52_29 VGND VGND VPWR VPWR sky130_fd_sc_hd__decap_8
XFILLER_22_100 VPWR VGND VPWR VGND sky130_ef_sc_hd__decap_12
XFILLER_22_155 VGND VGND VPWR VPWR sky130_fd_sc_hd__fill_2
XFILLER_22_188 VGND VGND VPWR VPWR sky130_fd_sc_hd__decap_8
XFILLER_60_217 VGND VGND VPWR VPWR sky130_fd_sc_hd__decap_3
XFILLER_45_203 VPWR VGND VPWR VGND sky130_ef_sc_hd__decap_12
XFILLER_26_85 VGND VGND VPWR VPWR sky130_fd_sc_hd__fill_2
XFILLER_13_111 VGND VGND VPWR VPWR sky130_fd_sc_hd__fill_1
XFILLER_9_137 VPWR VGND VPWR VGND sky130_ef_sc_hd__decap_12
X_1270_ _0576_ _0583_ _0594_ VGND VGND VPWR VPWR _0595_ sky130_fd_sc_hd__o21a_1
X_0985_ _0301_ _0315_ _0316_ VGND VGND VPWR VPWR _0318_ sky130_fd_sc_hd__nand3_1
XFILLER_8_170 VPWR VGND VPWR VGND sky130_ef_sc_hd__decap_12
Xfanout116 _0083_ VGND VGND VPWR VPWR net116 sky130_fd_sc_hd__clkbuf_4
Xfanout105 net106 VGND VGND VPWR VPWR net105 sky130_fd_sc_hd__clkbuf_4
X_1399_ clknet_3_3__leaf_clk _0015_ VGND VGND VPWR VPWR net48 sky130_fd_sc_hd__dfxtp_1
XFILLER_63_39 VPWR VGND VPWR VGND sky130_ef_sc_hd__decap_12
XFILLER_27_225 VPWR VGND VPWR VGND sky130_ef_sc_hd__decap_12
XTAP_TAPCELL_ROW_40_418 VGND VPWR sky130_fd_sc_hd__tapvpwrvgnd_1
XFILLER_12_54 VPWR VGND VPWR VGND sky130_ef_sc_hd__decap_12
XFILLER_2_357 VGND VGND VPWR VPWR sky130_fd_sc_hd__decap_6
XTAP_TAPCELL_ROW_5_173 VGND VPWR sky130_fd_sc_hd__tapvpwrvgnd_1
XFILLER_18_203 VGND VGND VPWR VPWR sky130_fd_sc_hd__fill_1
XFILLER_18_247 VGND VGND VPWR VPWR sky130_fd_sc_hd__decap_4
X_0770_ core_out\[19\] _0103_ VGND VGND VPWR VPWR _0131_ sky130_fd_sc_hd__and2_1
X_1322_ _0633_ _0635_ _0632_ VGND VGND VPWR VPWR _0639_ sky130_fd_sc_hd__o21a_1
XFILLER_56_309 VGND VGND VPWR VPWR sky130_fd_sc_hd__decap_4
X_1253_ _0528_ _0555_ VGND VGND VPWR VPWR _0579_ sky130_fd_sc_hd__and2b_1
X_1184_ _0504_ _0511_ VGND VGND VPWR VPWR _0512_ sky130_fd_sc_hd__nor2_1
XTAP_TAPCELL_ROW_19_275 VGND VPWR sky130_fd_sc_hd__tapvpwrvgnd_1
XTAP_TAPCELL_ROW_62_576 VGND VPWR sky130_fd_sc_hd__tapvpwrvgnd_1
X_0968_ _0293_ _0299_ VGND VGND VPWR VPWR _0301_ sky130_fd_sc_hd__xor2_1
XFILLER_32_250 VGND VGND VPWR VPWR sky130_fd_sc_hd__fill_2
XFILLER_20_401 VGND VGND VPWR VPWR sky130_fd_sc_hd__decap_6
X_0899_ _0230_ _0231_ _0232_ VGND VGND VPWR VPWR _0234_ sky130_fd_sc_hd__a21o_1
XFILLER_59_169 VGND VGND VPWR VPWR sky130_fd_sc_hd__fill_2
XFILLER_47_309 VGND VGND VPWR VPWR sky130_fd_sc_hd__fill_1
XTAP_TAPCELL_ROW_2_154 VGND VPWR sky130_fd_sc_hd__tapvpwrvgnd_1
XTAP_TAPCELL_ROW_53_510 VGND VPWR sky130_fd_sc_hd__tapvpwrvgnd_1
XFILLER_30_209 VPWR VGND VPWR VGND sky130_ef_sc_hd__decap_12
XFILLER_7_405 VGND VGND VPWR VPWR sky130_fd_sc_hd__fill_2
XFILLER_23_53 VGND VGND VPWR VPWR sky130_fd_sc_hd__decap_3
XFILLER_48_61 VPWR VGND VPWR VGND sky130_ef_sc_hd__decap_12
XFILLER_38_309 VGND VGND VPWR VPWR sky130_fd_sc_hd__decap_8
XFILLER_2_165 VPWR VGND VPWR VGND sky130_ef_sc_hd__decap_12
XFILLER_2_121 VPWR VGND VPWR VGND sky130_ef_sc_hd__decap_12
XFILLER_0_57 VPWR VGND VPWR VGND sky130_ef_sc_hd__decap_12
X_0822_ _0159_ _0160_ VGND VGND VPWR VPWR _0161_ sky130_fd_sc_hd__nor2_1
XFILLER_9_55 VGND VGND VPWR VPWR sky130_fd_sc_hd__fill_1
X_0753_ net155 net106 net57 _0122_ net116 VGND VGND VPWR VPWR _0019_ sky130_fd_sc_hd__o221a_1
XFILLER_56_139 VGND VGND VPWR VPWR sky130_fd_sc_hd__fill_1
X_1305_ _0618_ _0623_ VGND VGND VPWR VPWR _0625_ sky130_fd_sc_hd__nand2_1
X_1236_ net65 net66 net80 VGND VGND VPWR VPWR _0562_ sky130_fd_sc_hd__mux2_1
XFILLER_64_161 VGND VGND VPWR VPWR sky130_fd_sc_hd__decap_6
X_1167_ _0494_ _0495_ net98 VGND VGND VPWR VPWR _0496_ sky130_fd_sc_hd__o21ai_1
X_1098_ _0424_ _0427_ VGND VGND VPWR VPWR _0428_ sky130_fd_sc_hd__and2_1
XFILLER_60_29 VPWR VGND VPWR VGND sky130_ef_sc_hd__decap_12
Xtop_117 VGND VGND VPWR VPWR ready top_117/LO sky130_fd_sc_hd__conb_1
XFILLER_20_242 VGND VGND VPWR VPWR sky130_fd_sc_hd__fill_1
XFILLER_20_253 VGND VGND VPWR VPWR sky130_fd_sc_hd__fill_1
XFILLER_62_109 VPWR VGND VPWR VGND sky130_ef_sc_hd__decap_12
XFILLER_43_301 VPWR VGND VPWR VGND sky130_ef_sc_hd__decap_12
XFILLER_28_397 VGND VGND VPWR VPWR sky130_fd_sc_hd__fill_2
XFILLER_28_342 VPWR VGND VPWR VGND sky130_ef_sc_hd__decap_12
XFILLER_34_41 VPWR VGND VPWR VGND sky130_ef_sc_hd__decap_12
XFILLER_11_275 VGND VGND VPWR VPWR sky130_fd_sc_hd__decap_4
XFILLER_7_279 VGND VGND VPWR VPWR sky130_fd_sc_hd__fill_1
XFILLER_59_93 VGND VGND VPWR VPWR sky130_fd_sc_hd__decap_3
XFILLER_38_139 VGND VGND VPWR VPWR sky130_fd_sc_hd__fill_1
XFILLER_15_6 VPWR VGND VPWR VGND sky130_ef_sc_hd__decap_12
XFILLER_53_109 VGND VGND VPWR VPWR sky130_fd_sc_hd__decap_3
XFILLER_46_194 VGND VGND VPWR VPWR sky130_fd_sc_hd__fill_2
XFILLER_46_161 VPWR VGND VPWR VGND sky130_ef_sc_hd__decap_12
XFILLER_34_301 VGND VGND VPWR VPWR sky130_fd_sc_hd__decap_6
X_1021_ net77 net132 net81 VGND VGND VPWR VPWR _0353_ sky130_fd_sc_hd__o21a_1
X_0805_ net70 net15 _0144_ VGND VGND VPWR VPWR _0149_ sky130_fd_sc_hd__mux2_1
X_0736_ net87 net63 _0100_ net71 VGND VGND VPWR VPWR _0112_ sky130_fd_sc_hd__a22o_1
XFILLER_55_18 VPWR VGND VPWR VGND sky130_ef_sc_hd__decap_12
XFILLER_29_117 VGND VGND VPWR VPWR sky130_fd_sc_hd__fill_1
XTAP_TAPCELL_ROW_27_329 VGND VPWR sky130_fd_sc_hd__tapvpwrvgnd_1
XFILLER_25_334 VGND VGND VPWR VPWR sky130_fd_sc_hd__fill_2
X_1219_ _0544_ _0545_ VGND VGND VPWR VPWR _0546_ sky130_fd_sc_hd__nand2_1
XFILLER_52_153 VPWR VGND VPWR VGND sky130_ef_sc_hd__decap_12
XTAP_TAPCELL_ROW_35_384 VGND VPWR sky130_fd_sc_hd__tapvpwrvgnd_1
XTAP_TAPCELL_ROW_10_207 VGND VPWR sky130_fd_sc_hd__tapvpwrvgnd_1
Xhold41 net37 VGND VGND VPWR VPWR net157 sky130_fd_sc_hd__dlygate4sd3_1
Xhold52 core_out\[9\] VGND VGND VPWR VPWR net168 sky130_fd_sc_hd__dlygate4sd3_1
Xhold63 core_out\[15\] VGND VGND VPWR VPWR net179 sky130_fd_sc_hd__dlygate4sd3_1
Xhold30 net25 VGND VGND VPWR VPWR net146 sky130_fd_sc_hd__dlygate4sd3_1
XFILLER_28_161 VGND VGND VPWR VPWR sky130_fd_sc_hd__decap_3
XFILLER_16_345 VPWR VGND VPWR VGND sky130_ef_sc_hd__decap_12
XFILLER_16_389 VPWR VGND VPWR VGND sky130_ef_sc_hd__decap_12
XFILLER_43_197 VGND VGND VPWR VPWR sky130_fd_sc_hd__decap_4
XFILLER_31_337 VGND VGND VPWR VPWR sky130_fd_sc_hd__decap_8
XFILLER_3_293 VPWR VGND VPWR VGND sky130_ef_sc_hd__decap_12
XFILLER_13_3 VPWR VGND VPWR VGND sky130_ef_sc_hd__decap_12
X_1004_ _0292_ _0327_ _0326_ VGND VGND VPWR VPWR _0336_ sky130_fd_sc_hd__a21bo_1
XFILLER_34_197 VPWR VGND VPWR VGND sky130_ef_sc_hd__decap_12
XFILLER_34_153 VPWR VGND VPWR VGND sky130_ef_sc_hd__decap_12
XTAP_TAPCELL_ROW_32_365 VGND VPWR sky130_fd_sc_hd__tapvpwrvgnd_1
XFILLER_19_194 VPWR VGND VPWR VGND sky130_ef_sc_hd__decap_12
XFILLER_22_304 VGND VGND VPWR VPWR sky130_fd_sc_hd__decap_4
X_0719_ net2 net1 net3 VGND VGND VPWR VPWR _0099_ sky130_fd_sc_hd__or3b_2
XFILLER_40_101 VPWR VGND VPWR VGND sky130_ef_sc_hd__decap_12
XFILLER_13_337 VPWR VGND VPWR VGND sky130_ef_sc_hd__decap_12
Xoutput42 net42 VGND VGND VPWR VPWR rdata[2] sky130_fd_sc_hd__buf_2
XFILLER_31_97 VGND VGND VPWR VPWR sky130_fd_sc_hd__decap_4
Xoutput31 net31 VGND VGND VPWR VPWR rdata[1] sky130_fd_sc_hd__buf_2
Xoutput20 net20 VGND VGND VPWR VPWR rdata[0] sky130_fd_sc_hd__buf_2
XFILLER_56_83 VGND VGND VPWR VPWR sky130_fd_sc_hd__fill_1
XFILLER_48_289 VPWR VGND VPWR VGND sky130_ef_sc_hd__decap_12
XFILLER_48_201 VGND VGND VPWR VPWR sky130_fd_sc_hd__fill_1
XFILLER_16_153 VGND VGND VPWR VPWR sky130_fd_sc_hd__fill_2
XFILLER_16_175 VGND VGND VPWR VPWR sky130_fd_sc_hd__decap_4
XFILLER_16_197 VPWR VGND VPWR VGND sky130_ef_sc_hd__decap_12
XFILLER_8_363 VGND VGND VPWR VPWR sky130_fd_sc_hd__fill_1
XFILLER_54_248 VGND VGND VPWR VPWR sky130_fd_sc_hd__decap_4
XTAP_TAPCELL_ROW_37_402 VGND VPWR sky130_fd_sc_hd__tapvpwrvgnd_1
XFILLER_52_19 VGND VGND VPWR VPWR sky130_fd_sc_hd__decap_8
XFILLER_10_307 VGND VGND VPWR VPWR sky130_fd_sc_hd__fill_1
XFILLER_22_112 VPWR VGND VPWR VGND sky130_ef_sc_hd__decap_12
XFILLER_45_215 VGND VGND VPWR VPWR sky130_fd_sc_hd__decap_8
XFILLER_53_281 VPWR VGND VPWR VGND sky130_ef_sc_hd__decap_12
Xclkbuf_3_6__f_clk clknet_0_clk VGND VGND VPWR VPWR clknet_3_6__leaf_clk sky130_fd_sc_hd__clkbuf_16
XTAP_TAPCELL_ROW_43_438 VGND VPWR sky130_fd_sc_hd__tapvpwrvgnd_1
XFILLER_42_41 VPWR VGND VPWR VGND sky130_ef_sc_hd__decap_12
Xrebuffer8 _0264_ VGND VGND VPWR VPWR net124 sky130_fd_sc_hd__dlymetal6s2s_1
XFILLER_9_149 VGND VGND VPWR VPWR sky130_fd_sc_hd__decap_8
XFILLER_3_57 VPWR VGND VPWR VGND sky130_ef_sc_hd__decap_12
XTAP_TAPCELL_ROW_8_193 VGND VPWR sky130_fd_sc_hd__tapvpwrvgnd_1
XFILLER_51_207 VPWR VGND VPWR VGND sky130_ef_sc_hd__decap_12
X_0984_ _0301_ _0315_ _0316_ VGND VGND VPWR VPWR _0317_ sky130_fd_sc_hd__and3_1
X_1398_ clknet_3_2__leaf_clk _0014_ VGND VGND VPWR VPWR net47 sky130_fd_sc_hd__dfxtp_1
Xfanout106 _0101_ VGND VGND VPWR VPWR net106 sky130_fd_sc_hd__clkbuf_4
XFILLER_50_251 VGND VGND VPWR VPWR sky130_fd_sc_hd__fill_1
XFILLER_35_281 VGND VGND VPWR VPWR sky130_fd_sc_hd__fill_2
XFILLER_27_237 VPWR VGND VPWR VGND sky130_ef_sc_hd__decap_12
XPHY_EDGE_ROW_19_Left_84 VGND VGND VPWR VPWR sky130_fd_sc_hd__decap_3
XTAP_TAPCELL_ROW_40_419 VGND VPWR sky130_fd_sc_hd__tapvpwrvgnd_1
XFILLER_12_66 VGND VGND VPWR VPWR sky130_fd_sc_hd__fill_1
XTAP_TAPCELL_ROW_56_530 VGND VPWR sky130_fd_sc_hd__tapvpwrvgnd_1
XFILLER_37_63 VPWR VGND VPWR VGND sky130_ef_sc_hd__decap_12
XFILLER_37_41 VGND VGND VPWR VPWR sky130_fd_sc_hd__fill_2
XTAP_TAPCELL_ROW_5_174 VGND VPWR sky130_fd_sc_hd__tapvpwrvgnd_1
XFILLER_52_7 VPWR VGND VPWR VGND sky130_ef_sc_hd__decap_12
XFILLER_45_6 VPWR VGND VPWR VGND sky130_ef_sc_hd__decap_12
X_1321_ core_out\[23\] net54 VGND VGND VPWR VPWR _0638_ sky130_fd_sc_hd__xnor2_1
X_1252_ _0576_ _0577_ VGND VGND VPWR VPWR _0578_ sky130_fd_sc_hd__or2_1
XFILLER_1_391 VGND VGND VPWR VPWR sky130_fd_sc_hd__fill_1
XFILLER_64_365 VPWR VGND VPWR VGND sky130_ef_sc_hd__decap_12
X_1183_ _0467_ _0510_ VGND VGND VPWR VPWR _0511_ sky130_fd_sc_hd__xnor2_1
XFILLER_17_281 VPWR VGND VPWR VGND sky130_ef_sc_hd__decap_12
XTAP_TAPCELL_ROW_19_276 VGND VPWR sky130_fd_sc_hd__tapvpwrvgnd_1
XFILLER_24_218 VPWR VGND VPWR VGND sky130_ef_sc_hd__decap_12
XTAP_TAPCELL_ROW_62_577 VGND VPWR sky130_fd_sc_hd__tapvpwrvgnd_1
X_0967_ _0293_ _0299_ VGND VGND VPWR VPWR _0300_ sky130_fd_sc_hd__nand2_1
XFILLER_58_29 VPWR VGND VPWR VGND sky130_ef_sc_hd__decap_12
X_0898_ _0230_ _0231_ _0232_ VGND VGND VPWR VPWR _0233_ sky130_fd_sc_hd__nand3_1
XPHY_EDGE_ROW_12_Right_12 VGND VGND VPWR VPWR sky130_fd_sc_hd__decap_3
XTAP_TAPCELL_ROW_2_155 VGND VPWR sky130_fd_sc_hd__tapvpwrvgnd_1
XPHY_EDGE_ROW_21_Right_21 VGND VGND VPWR VPWR sky130_fd_sc_hd__decap_3
XTAP_TAPCELL_ROW_53_511 VGND VPWR sky130_fd_sc_hd__tapvpwrvgnd_1
XPHY_EDGE_ROW_4_Left_69 VGND VGND VPWR VPWR sky130_fd_sc_hd__decap_3
XFILLER_23_262 VGND VGND VPWR VPWR sky130_fd_sc_hd__fill_2
XFILLER_23_295 VGND VGND VPWR VPWR sky130_fd_sc_hd__fill_1
XPHY_EDGE_ROW_30_Right_30 VGND VGND VPWR VPWR sky130_fd_sc_hd__decap_3
XFILLER_48_73 VGND VGND VPWR VPWR sky130_fd_sc_hd__decap_6
XFILLER_2_177 VPWR VGND VPWR VGND sky130_ef_sc_hd__decap_12
XFILLER_2_133 VGND VGND VPWR VPWR sky130_fd_sc_hd__decap_6
XFILLER_61_335 VGND VGND VPWR VPWR sky130_fd_sc_hd__fill_1
XFILLER_46_365 VGND VGND VPWR VPWR sky130_fd_sc_hd__fill_1
XFILLER_0_69 VPWR VGND VPWR VGND sky130_ef_sc_hd__decap_12
X_0752_ core_out\[10\] net61 VGND VGND VPWR VPWR _0122_ sky130_fd_sc_hd__and2_1
X_0821_ _0156_ _0158_ core_out\[1\] VGND VGND VPWR VPWR _0160_ sky130_fd_sc_hd__a21oi_1
XFILLER_14_251 VGND VGND VPWR VPWR sky130_fd_sc_hd__fill_1
XFILLER_43_3 VGND VGND VPWR VPWR sky130_fd_sc_hd__fill_2
X_1304_ _0618_ _0623_ VGND VGND VPWR VPWR _0624_ sky130_fd_sc_hd__or2_4
XFILLER_49_181 VPWR VGND VPWR VGND sky130_ef_sc_hd__decap_12
X_1166_ _0459_ _0462_ _0493_ VGND VGND VPWR VPWR _0495_ sky130_fd_sc_hd__and3_1
X_1235_ _0535_ _0538_ _0540_ VGND VGND VPWR VPWR _0561_ sky130_fd_sc_hd__a21o_1
XFILLER_64_195 VGND VGND VPWR VPWR sky130_fd_sc_hd__fill_1
X_1097_ _0425_ _0426_ VGND VGND VPWR VPWR _0427_ sky130_fd_sc_hd__nor2_1
XFILLER_20_287 VPWR VGND VPWR VGND sky130_ef_sc_hd__decap_12
XFILLER_55_195 VGND VGND VPWR VPWR sky130_fd_sc_hd__fill_1
XFILLER_55_184 VGND VGND VPWR VPWR sky130_fd_sc_hd__decap_4
XFILLER_43_313 VPWR VGND VPWR VGND sky130_ef_sc_hd__decap_12
XFILLER_28_365 VPWR VGND VPWR VGND sky130_ef_sc_hd__decap_12
XFILLER_28_354 VGND VGND VPWR VPWR sky130_fd_sc_hd__decap_8
XFILLER_18_98 VPWR VGND VPWR VGND sky130_ef_sc_hd__decap_12
XFILLER_34_53 VPWR VGND VPWR VGND sky130_ef_sc_hd__decap_12
XFILLER_7_203 VPWR VGND VPWR VGND sky130_ef_sc_hd__decap_12
XFILLER_7_225 VPWR VGND VPWR VGND sky130_ef_sc_hd__decap_12
XFILLER_7_247 VPWR VGND VPWR VGND sky130_ef_sc_hd__decap_12
XFILLER_50_85 VGND VGND VPWR VPWR sky130_fd_sc_hd__decap_4
X_1020_ net77 net79 net81 VGND VGND VPWR VPWR _0352_ sky130_fd_sc_hd__o21ai_2
XFILLER_46_173 VGND VGND VPWR VPWR sky130_fd_sc_hd__decap_3
XFILLER_42_390 VPWR VGND VPWR VGND sky130_ef_sc_hd__decap_12
X_0735_ net137 net107 _0111_ net110 VGND VGND VPWR VPWR _0012_ sky130_fd_sc_hd__o211a_1
X_0804_ net108 _0148_ VGND VGND VPWR VPWR _0044_ sky130_fd_sc_hd__and2_1
XFILLER_57_405 VGND VGND VPWR VPWR sky130_fd_sc_hd__fill_2
XFILLER_29_129 VPWR VGND VPWR VGND sky130_ef_sc_hd__decap_12
XFILLER_25_302 VPWR VGND VPWR VGND sky130_ef_sc_hd__decap_12
X_1218_ _0503_ _0512_ _0543_ VGND VGND VPWR VPWR _0545_ sky130_fd_sc_hd__or3_1
X_1149_ _0431_ _0439_ _0399_ VGND VGND VPWR VPWR _0478_ sky130_fd_sc_hd__o21ai_1
XFILLER_52_165 VPWR VGND VPWR VGND sky130_ef_sc_hd__decap_12
XTAP_TAPCELL_ROW_35_385 VGND VPWR sky130_fd_sc_hd__tapvpwrvgnd_1
XTAP_TAPCELL_ROW_10_208 VGND VPWR sky130_fd_sc_hd__tapvpwrvgnd_1
Xhold31 net35 VGND VGND VPWR VPWR net147 sky130_fd_sc_hd__dlygate4sd3_1
Xhold42 net28 VGND VGND VPWR VPWR net158 sky130_fd_sc_hd__dlygate4sd3_1
Xhold64 core_out\[24\] VGND VGND VPWR VPWR net180 sky130_fd_sc_hd__dlygate4sd3_1
Xhold53 core_out\[14\] VGND VGND VPWR VPWR net169 sky130_fd_sc_hd__dlygate4sd3_1
Xhold20 net31 VGND VGND VPWR VPWR net136 sky130_fd_sc_hd__dlygate4sd3_1
XFILLER_45_52 VGND VGND VPWR VPWR sky130_fd_sc_hd__fill_1
XFILLER_28_195 VGND VGND VPWR VPWR sky130_fd_sc_hd__fill_1
XFILLER_16_357 VGND VGND VPWR VPWR sky130_fd_sc_hd__decap_6
XFILLER_61_51 VGND VGND VPWR VPWR sky130_fd_sc_hd__decap_4
XPHY_EDGE_ROW_7_Left_72 VGND VGND VPWR VPWR sky130_fd_sc_hd__decap_3
XFILLER_39_405 VGND VGND VPWR VPWR sky130_fd_sc_hd__fill_2
XFILLER_3_261 VPWR VGND VPWR VGND sky130_ef_sc_hd__decap_12
X_1003_ net100 net167 net112 _0335_ VGND VGND VPWR VPWR _0056_ sky130_fd_sc_hd__o211a_1
Xrebuffer18 _0555_ VGND VGND VPWR VPWR net134 sky130_fd_sc_hd__dlygate4sd1_1
XFILLER_34_165 VGND VGND VPWR VPWR sky130_fd_sc_hd__decap_8
XTAP_TAPCELL_ROW_32_366 VGND VPWR sky130_fd_sc_hd__tapvpwrvgnd_1
XPHY_EDGE_ROW_6_Right_6 VGND VGND VPWR VPWR sky130_fd_sc_hd__decap_3
X_0718_ net108 _0098_ VGND VGND VPWR VPWR _0008_ sky130_fd_sc_hd__and2_1
XFILLER_57_235 VGND VGND VPWR VPWR sky130_fd_sc_hd__decap_6
XFILLER_57_279 VGND VGND VPWR VPWR sky130_fd_sc_hd__fill_1
XFILLER_40_113 VPWR VGND VPWR VGND sky130_ef_sc_hd__decap_12
XFILLER_13_305 VPWR VGND VPWR VGND sky130_ef_sc_hd__decap_12
XFILLER_13_349 VPWR VGND VPWR VGND sky130_ef_sc_hd__decap_12
XFILLER_15_55 VGND VGND VPWR VPWR sky130_fd_sc_hd__fill_1
XTAP_TAPCELL_ROW_23_300 VGND VPWR sky130_fd_sc_hd__tapvpwrvgnd_1
XFILLER_25_154 VGND VGND VPWR VPWR sky130_fd_sc_hd__decap_4
XFILLER_31_54 VGND VGND VPWR VPWR sky130_fd_sc_hd__fill_2
XFILLER_21_393 VPWR VGND VPWR VGND sky130_ef_sc_hd__decap_12
Xoutput43 net43 VGND VGND VPWR VPWR rdata[30] sky130_fd_sc_hd__buf_2
Xoutput32 net32 VGND VGND VPWR VPWR rdata[20] sky130_fd_sc_hd__buf_2
XPHY_EDGE_ROW_33_Left_98 VGND VGND VPWR VPWR sky130_fd_sc_hd__decap_3
Xoutput21 net21 VGND VGND VPWR VPWR rdata[10] sky130_fd_sc_hd__buf_2
XFILLER_0_253 VPWR VGND VPWR VGND sky130_ef_sc_hd__decap_12
XFILLER_63_249 VGND VGND VPWR VPWR sky130_fd_sc_hd__decap_4
XPHY_EDGE_ROW_59_Right_59 VGND VGND VPWR VPWR sky130_fd_sc_hd__decap_3
XFILLER_62_293 VGND VGND VPWR VPWR sky130_fd_sc_hd__decap_6
XFILLER_39_279 VGND VGND VPWR VPWR sky130_fd_sc_hd__fill_1
XFILLER_22_124 VGND VGND VPWR VPWR sky130_fd_sc_hd__decap_8
XTAP_TAPCELL_ROW_43_439 VGND VPWR sky130_fd_sc_hd__tapvpwrvgnd_1
XFILLER_42_53 VGND VGND VPWR VPWR sky130_fd_sc_hd__decap_4
XFILLER_13_113 VGND VGND VPWR VPWR sky130_fd_sc_hd__decap_8
XTAP_TAPCELL_ROW_51_494 VGND VPWR sky130_fd_sc_hd__tapvpwrvgnd_1
Xrebuffer9 _0264_ VGND VGND VPWR VPWR net125 sky130_fd_sc_hd__dlygate4sd1_1
XFILLER_3_69 VPWR VGND VPWR VGND sky130_ef_sc_hd__decap_12
XTAP_TAPCELL_ROW_8_194 VGND VPWR sky130_fd_sc_hd__tapvpwrvgnd_1
XTAP_TAPCELL_ROW_59_550 VGND VPWR sky130_fd_sc_hd__tapvpwrvgnd_1
XFILLER_51_219 VGND VGND VPWR VPWR sky130_fd_sc_hd__decap_4
X_0983_ _0312_ _0313_ _0314_ VGND VGND VPWR VPWR _0316_ sky130_fd_sc_hd__a21o_1
Xfanout107 _0101_ VGND VGND VPWR VPWR net107 sky130_fd_sc_hd__clkbuf_4
XFILLER_8_194 VGND VGND VPWR VPWR sky130_fd_sc_hd__fill_2
X_1397_ clknet_3_2__leaf_clk _0013_ VGND VGND VPWR VPWR net46 sky130_fd_sc_hd__dfxtp_1
XFILLER_27_249 VPWR VGND VPWR VGND sky130_ef_sc_hd__decap_12
XFILLER_6_109 VPWR VGND VPWR VGND sky130_ef_sc_hd__decap_12
XFILLER_12_89 VGND VGND VPWR VPWR sky130_fd_sc_hd__fill_1
XFILLER_58_363 VGND VGND VPWR VPWR sky130_fd_sc_hd__fill_1
XTAP_TAPCELL_ROW_56_531 VGND VPWR sky130_fd_sc_hd__tapvpwrvgnd_1
XFILLER_37_75 VGND VGND VPWR VPWR sky130_fd_sc_hd__decap_4
XFILLER_33_208 VGND VGND VPWR VPWR sky130_fd_sc_hd__fill_1
XTAP_TAPCELL_ROW_5_175 VGND VPWR sky130_fd_sc_hd__tapvpwrvgnd_1
XFILLER_41_241 VGND VGND VPWR VPWR sky130_fd_sc_hd__fill_1
X_1320_ net102 core_out\[22\] net114 _0637_ VGND VGND VPWR VPWR _0071_ sky130_fd_sc_hd__o211a_1
X_1251_ core_out\[14\] _0574_ VGND VGND VPWR VPWR _0577_ sky130_fd_sc_hd__nor2_1
X_1182_ _0505_ _0508_ VGND VGND VPWR VPWR _0510_ sky130_fd_sc_hd__xor2_1
XFILLER_64_377 VPWR VGND VPWR VGND sky130_ef_sc_hd__decap_12
XFILLER_32_274 VGND VGND VPWR VPWR sky130_fd_sc_hd__decap_3
XFILLER_17_293 VPWR VGND VPWR VGND sky130_ef_sc_hd__decap_12
XPHY_EDGE_ROW_20_Left_85 VGND VGND VPWR VPWR sky130_fd_sc_hd__decap_3
X_0897_ _0200_ _0202_ _0201_ VGND VGND VPWR VPWR _0232_ sky130_fd_sc_hd__o21bai_1
X_0966_ _0297_ _0298_ VGND VGND VPWR VPWR _0299_ sky130_fd_sc_hd__nor2_1
X_1449_ clknet_3_4__leaf_clk _0065_ VGND VGND VPWR VPWR core_out\[16\] sky130_fd_sc_hd__dfxtp_1
XFILLER_55_311 VGND VGND VPWR VPWR sky130_fd_sc_hd__decap_6
XTAP_TAPCELL_ROW_53_512 VGND VPWR sky130_fd_sc_hd__tapvpwrvgnd_1
XTAP_TAPCELL_ROW_2_156 VGND VPWR sky130_fd_sc_hd__tapvpwrvgnd_1
XFILLER_3_3 VPWR VGND VPWR VGND sky130_ef_sc_hd__decap_12
XFILLER_23_99 VGND VGND VPWR VPWR sky130_fd_sc_hd__decap_4
XFILLER_58_193 VGND VGND VPWR VPWR sky130_fd_sc_hd__decap_3
XFILLER_48_85 VGND VGND VPWR VPWR sky130_fd_sc_hd__decap_4
XFILLER_2_189 VGND VGND VPWR VPWR sky130_fd_sc_hd__decap_6
XFILLER_0_15 VPWR VGND VPWR VGND sky130_ef_sc_hd__decap_12
X_0751_ net165 net106 net57 _0121_ net113 VGND VGND VPWR VPWR _0018_ sky130_fd_sc_hd__o221a_1
X_0820_ core_out\[1\] _0156_ _0158_ VGND VGND VPWR VPWR _0159_ sky130_fd_sc_hd__and3_1
XFILLER_9_57 VPWR VGND VPWR VGND sky130_ef_sc_hd__decap_12
X_1303_ _0620_ _0622_ VGND VGND VPWR VPWR _0623_ sky130_fd_sc_hd__and2_4
XFILLER_64_141 VPWR VGND VPWR VGND sky130_ef_sc_hd__decap_12
XFILLER_49_193 VGND VGND VPWR VPWR sky130_fd_sc_hd__decap_8
X_1165_ _0459_ _0462_ _0493_ VGND VGND VPWR VPWR _0494_ sky130_fd_sc_hd__a21oi_2
X_1096_ net88 net86 net66 net65 VGND VGND VPWR VPWR _0426_ sky130_fd_sc_hd__and4b_1
X_1234_ _0524_ _0522_ _0553_ _0559_ VGND VGND VPWR VPWR _0560_ sky130_fd_sc_hd__a31o_1
X_0949_ _0280_ _0281_ _0243_ VGND VGND VPWR VPWR _0283_ sky130_fd_sc_hd__o21ai_1
XFILLER_20_299 VGND VGND VPWR VPWR sky130_fd_sc_hd__decap_8
XFILLER_47_108 VGND VGND VPWR VPWR sky130_fd_sc_hd__decap_4
XFILLER_43_325 VGND VGND VPWR VPWR sky130_fd_sc_hd__fill_2
XFILLER_28_377 VPWR VGND VPWR VGND sky130_ef_sc_hd__decap_12
XFILLER_18_66 VGND VGND VPWR VPWR sky130_fd_sc_hd__fill_2
XFILLER_18_77 VGND VGND VPWR VPWR sky130_fd_sc_hd__fill_1
XFILLER_51_391 VGND VGND VPWR VPWR sky130_fd_sc_hd__fill_1
XFILLER_34_65 VPWR VGND VPWR VGND sky130_ef_sc_hd__decap_12
XFILLER_7_215 VGND VGND VPWR VPWR sky130_fd_sc_hd__decap_8
XFILLER_7_237 VGND VGND VPWR VPWR sky130_fd_sc_hd__decap_3
XFILLER_7_259 VPWR VGND VPWR VGND sky130_ef_sc_hd__decap_12
XFILLER_11_222 VGND VGND VPWR VPWR sky130_fd_sc_hd__fill_2
XTAP_TAPCELL_ROW_13_228 VGND VPWR sky130_fd_sc_hd__tapvpwrvgnd_1
XFILLER_59_51 VGND VGND VPWR VPWR sky130_fd_sc_hd__decap_4
XFILLER_50_97 VPWR VGND VPWR VGND sky130_ef_sc_hd__decap_12
XFILLER_46_141 VGND VGND VPWR VPWR sky130_fd_sc_hd__decap_4
XFILLER_19_311 VPWR VGND VPWR VGND sky130_ef_sc_hd__decap_12
XFILLER_61_188 VPWR VGND VPWR VGND sky130_ef_sc_hd__decap_12
XFILLER_61_177 VGND VGND VPWR VPWR sky130_fd_sc_hd__fill_2
XFILLER_61_111 VGND VGND VPWR VPWR sky130_fd_sc_hd__fill_1
X_0734_ net89 _0089_ _0102_ _0110_ VGND VGND VPWR VPWR _0111_ sky130_fd_sc_hd__a211o_1
X_0803_ net73 net14 _0144_ VGND VGND VPWR VPWR _0148_ sky130_fd_sc_hd__mux2_1
XFILLER_52_177 VGND VGND VPWR VPWR sky130_fd_sc_hd__decap_8
XFILLER_52_111 VPWR VGND VPWR VGND sky130_ef_sc_hd__decap_12
X_1079_ _0342_ _0344_ _0408_ _0409_ VGND VGND VPWR VPWR _0410_ sky130_fd_sc_hd__a211oi_2
XFILLER_25_314 VPWR VGND VPWR VGND sky130_ef_sc_hd__decap_12
X_1217_ _0503_ _0512_ _0543_ VGND VGND VPWR VPWR _0544_ sky130_fd_sc_hd__o21ai_1
X_1148_ _0432_ _0476_ VGND VGND VPWR VPWR _0477_ sky130_fd_sc_hd__xnor2_1
XFILLER_40_328 VPWR VGND VPWR VGND sky130_ef_sc_hd__decap_12
XTAP_TAPCELL_ROW_35_386 VGND VPWR sky130_fd_sc_hd__tapvpwrvgnd_1
XFILLER_33_391 VGND VGND VPWR VPWR sky130_fd_sc_hd__fill_1
XTAP_TAPCELL_ROW_10_209 VGND VPWR sky130_fd_sc_hd__tapvpwrvgnd_1
XPHY_EDGE_ROW_42_Left_107 VGND VGND VPWR VPWR sky130_fd_sc_hd__decap_3
Xhold32 net49 VGND VGND VPWR VPWR net148 sky130_fd_sc_hd__dlygate4sd3_1
Xhold43 net44 VGND VGND VPWR VPWR net159 sky130_fd_sc_hd__dlygate4sd3_1
Xhold65 core_out\[20\] VGND VGND VPWR VPWR net181 sky130_fd_sc_hd__dlygate4sd3_1
Xhold21 net45 VGND VGND VPWR VPWR net137 sky130_fd_sc_hd__dlygate4sd3_1
Xhold54 core_out\[1\] VGND VGND VPWR VPWR net170 sky130_fd_sc_hd__dlygate4sd3_1
XFILLER_29_54 VGND VGND VPWR VPWR sky130_fd_sc_hd__fill_2
XFILLER_28_141 VPWR VGND VPWR VGND sky130_ef_sc_hd__decap_12
XPHY_EDGE_ROW_51_Left_116 VGND VGND VPWR VPWR sky130_fd_sc_hd__decap_3
XFILLER_43_133 VPWR VGND VPWR VGND sky130_ef_sc_hd__decap_12
XFILLER_31_317 VPWR VGND VPWR VGND sky130_ef_sc_hd__decap_12
XTAP_TAPCELL_ROW_26_320 VGND VPWR sky130_fd_sc_hd__tapvpwrvgnd_1
XPHY_EDGE_ROW_60_Left_125 VGND VGND VPWR VPWR sky130_fd_sc_hd__decap_3
XFILLER_3_273 VGND VGND VPWR VPWR sky130_fd_sc_hd__decap_6
X_1002_ _0333_ _0334_ net100 VGND VGND VPWR VPWR _0335_ sky130_fd_sc_hd__a21bo_1
XTAP_TAPCELL_ROW_32_367 VGND VPWR sky130_fd_sc_hd__tapvpwrvgnd_1
XFILLER_30_350 VPWR VGND VPWR VGND sky130_ef_sc_hd__decap_12
XFILLER_15_391 VGND VGND VPWR VPWR sky130_fd_sc_hd__fill_1
X_0717_ net80 net18 _0090_ VGND VGND VPWR VPWR _0098_ sky130_fd_sc_hd__mux2_1
XFILLER_57_225 VGND VGND VPWR VPWR sky130_fd_sc_hd__fill_2
XFILLER_40_125 VPWR VGND VPWR VGND sky130_ef_sc_hd__decap_12
XFILLER_13_317 VPWR VGND VPWR VGND sky130_ef_sc_hd__decap_12
XTAP_TAPCELL_ROW_23_301 VGND VPWR sky130_fd_sc_hd__tapvpwrvgnd_1
XFILLER_25_100 VPWR VGND VPWR VGND sky130_ef_sc_hd__decap_12
XFILLER_25_133 VGND VGND VPWR VPWR sky130_fd_sc_hd__decap_3
XFILLER_25_177 VGND VGND VPWR VPWR sky130_fd_sc_hd__decap_8
XFILLER_31_77 VGND VGND VPWR VPWR sky130_fd_sc_hd__decap_3
XFILLER_21_361 VPWR VGND VPWR VGND sky130_ef_sc_hd__decap_12
Xoutput44 net44 VGND VGND VPWR VPWR rdata[31] sky130_fd_sc_hd__buf_2
Xoutput33 net33 VGND VGND VPWR VPWR rdata[21] sky130_fd_sc_hd__buf_2
Xoutput22 net22 VGND VGND VPWR VPWR rdata[11] sky130_fd_sc_hd__buf_2
XFILLER_0_221 VGND VGND VPWR VPWR sky130_fd_sc_hd__decap_3
XFILLER_0_265 VPWR VGND VPWR VGND sky130_ef_sc_hd__decap_12
XFILLER_56_85 VPWR VGND VPWR VGND sky130_ef_sc_hd__decap_12
XFILLER_56_41 VPWR VGND VPWR VGND sky130_ef_sc_hd__decap_12
XTAP_TAPCELL_ROW_46_459 VGND VPWR sky130_fd_sc_hd__tapvpwrvgnd_1
XFILLER_31_169 VPWR VGND VPWR VGND sky130_ef_sc_hd__decap_12
XFILLER_8_321 VPWR VGND VPWR VGND sky130_ef_sc_hd__decap_12
XFILLER_8_365 VPWR VGND VPWR VGND sky130_ef_sc_hd__decap_12
XFILLER_39_225 VPWR VGND VPWR VGND sky130_ef_sc_hd__decap_12
XFILLER_39_247 VPWR VGND VPWR VGND sky130_ef_sc_hd__decap_12
XFILLER_22_147 VGND VGND VPWR VPWR sky130_fd_sc_hd__decap_8
XFILLER_10_309 VPWR VGND VPWR VGND sky130_ef_sc_hd__decap_12
XFILLER_60_209 VGND VGND VPWR VPWR sky130_fd_sc_hd__decap_8
XFILLER_53_272 VGND VGND VPWR VPWR sky130_fd_sc_hd__decap_8
XTAP_TAPCELL_ROW_51_495 VGND VPWR sky130_fd_sc_hd__tapvpwrvgnd_1
XFILLER_42_65 VGND VGND VPWR VPWR sky130_fd_sc_hd__decap_4
XFILLER_13_103 VGND VGND VPWR VPWR sky130_fd_sc_hd__decap_8
XFILLER_13_169 VPWR VGND VPWR VGND sky130_ef_sc_hd__decap_12
XFILLER_5_335 VGND VGND VPWR VPWR sky130_fd_sc_hd__fill_1
XTAP_TAPCELL_ROW_59_551 VGND VPWR sky130_fd_sc_hd__tapvpwrvgnd_1
XFILLER_3_15 VPWR VGND VPWR VGND sky130_ef_sc_hd__decap_12
XTAP_TAPCELL_ROW_8_195 VGND VPWR sky130_fd_sc_hd__tapvpwrvgnd_1
XFILLER_44_250 VGND VGND VPWR VPWR sky130_fd_sc_hd__fill_2
X_0982_ _0312_ _0313_ _0314_ VGND VGND VPWR VPWR _0315_ sky130_fd_sc_hd__nand3_2
Xfanout108 net109 VGND VGND VPWR VPWR net108 sky130_fd_sc_hd__clkbuf_2
X_1396_ clknet_3_2__leaf_clk _0012_ VGND VGND VPWR VPWR net45 sky130_fd_sc_hd__dfxtp_1
XFILLER_42_209 VPWR VGND VPWR VGND sky130_ef_sc_hd__decap_12
XFILLER_27_217 VGND VGND VPWR VPWR sky130_fd_sc_hd__decap_6
XFILLER_50_264 VGND VGND VPWR VPWR sky130_fd_sc_hd__decap_6
XFILLER_50_253 VGND VGND VPWR VPWR sky130_fd_sc_hd__decap_4
XFILLER_35_261 VPWR VGND VPWR VGND sky130_ef_sc_hd__decap_12
XFILLER_10_139 VGND VGND VPWR VPWR sky130_fd_sc_hd__fill_1
XTAP_TAPCELL_ROW_5_176 VGND VPWR sky130_fd_sc_hd__tapvpwrvgnd_1
XTAP_TAPCELL_ROW_56_532 VGND VPWR sky130_fd_sc_hd__tapvpwrvgnd_1
XFILLER_14_401 VGND VGND VPWR VPWR sky130_fd_sc_hd__decap_6
XFILLER_38_7 VGND VGND VPWR VPWR sky130_fd_sc_hd__fill_1
X_1250_ _0575_ VGND VGND VPWR VPWR _0576_ sky130_fd_sc_hd__inv_2
XFILLER_1_393 VPWR VGND VPWR VGND sky130_ef_sc_hd__decap_12
X_1181_ _0505_ _0508_ VGND VGND VPWR VPWR _0509_ sky130_fd_sc_hd__and2_1
XFILLER_64_389 VGND VGND VPWR VPWR sky130_fd_sc_hd__decap_3
XFILLER_32_253 VGND VGND VPWR VPWR sky130_fd_sc_hd__decap_6
XFILLER_32_242 VGND VGND VPWR VPWR sky130_fd_sc_hd__decap_8
XFILLER_32_231 VGND VGND VPWR VPWR sky130_fd_sc_hd__fill_1
X_0896_ _0228_ _0229_ _0227_ VGND VGND VPWR VPWR _0231_ sky130_fd_sc_hd__o21ai_1
X_0965_ _0295_ _0296_ _0081_ net95 VGND VGND VPWR VPWR _0298_ sky130_fd_sc_hd__o2bb2a_1
X_1448_ clknet_3_5__leaf_clk _0064_ VGND VGND VPWR VPWR core_out\[15\] sky130_fd_sc_hd__dfxtp_1
X_1379_ core_out\[31\] net52 VGND VGND VPWR VPWR _0688_ sky130_fd_sc_hd__xnor2_1
XTAP_TAPCELL_ROW_53_513 VGND VPWR sky130_fd_sc_hd__tapvpwrvgnd_1
XTAP_TAPCELL_ROW_2_157 VGND VPWR sky130_fd_sc_hd__tapvpwrvgnd_1
XFILLER_23_45 VGND VGND VPWR VPWR sky130_fd_sc_hd__decap_8
XFILLER_23_67 VGND VGND VPWR VPWR sky130_fd_sc_hd__decap_4
XFILLER_0_27 VGND VGND VPWR VPWR sky130_fd_sc_hd__fill_1
XFILLER_64_85 VPWR VGND VPWR VGND sky130_ef_sc_hd__decap_12
XFILLER_64_41 VPWR VGND VPWR VGND sky130_ef_sc_hd__decap_12
XFILLER_61_337 VPWR VGND VPWR VGND sky130_ef_sc_hd__decap_12
XFILLER_61_315 VPWR VGND VPWR VGND sky130_ef_sc_hd__decap_12
XFILLER_9_69 VGND VGND VPWR VPWR sky130_fd_sc_hd__decap_8
XFILLER_14_253 VPWR VGND VPWR VGND sky130_ef_sc_hd__decap_12
XFILLER_50_6 VGND VGND VPWR VPWR sky130_fd_sc_hd__fill_1
X_0750_ core_out\[9\] net61 VGND VGND VPWR VPWR _0121_ sky130_fd_sc_hd__and2_1
Xfanout90 net91 VGND VGND VPWR VPWR net90 sky130_fd_sc_hd__clkbuf_2
XFILLER_56_109 VPWR VGND VPWR VGND sky130_ef_sc_hd__decap_12
X_1302_ _0621_ VGND VGND VPWR VPWR _0622_ sky130_fd_sc_hd__inv_2
XFILLER_29_3 VPWR VGND VPWR VGND sky130_ef_sc_hd__decap_12
X_1233_ _0519_ _0551_ _0550_ VGND VGND VPWR VPWR _0559_ sky130_fd_sc_hd__a21o_1
XFILLER_64_197 VPWR VGND VPWR VGND sky130_ef_sc_hd__decap_12
XFILLER_64_153 VGND VGND VPWR VPWR sky130_fd_sc_hd__decap_4
XFILLER_37_389 VGND VGND VPWR VPWR sky130_fd_sc_hd__decap_3
X_1164_ core_out\[11\] _0491_ VGND VGND VPWR VPWR _0493_ sky130_fd_sc_hd__xnor2_1
X_1095_ net67 net86 net88 _0081_ VGND VGND VPWR VPWR _0425_ sky130_fd_sc_hd__o2bb2a_1
X_0948_ _0243_ _0280_ _0281_ VGND VGND VPWR VPWR _0282_ sky130_fd_sc_hd__or3_1
XFILLER_20_234 VGND VGND VPWR VPWR sky130_fd_sc_hd__decap_8
XFILLER_20_267 VGND VGND VPWR VPWR sky130_fd_sc_hd__decap_4
X_0879_ core_out\[4\] _0213_ _0214_ VGND VGND VPWR VPWR _0215_ sky130_fd_sc_hd__and3_1
XFILLER_18_45 VGND VGND VPWR VPWR sky130_fd_sc_hd__fill_1
XFILLER_43_337 VGND VGND VPWR VPWR sky130_fd_sc_hd__decap_3
XFILLER_34_77 VGND VGND VPWR VPWR sky130_fd_sc_hd__decap_6
XFILLER_28_389 VGND VGND VPWR VPWR sky130_fd_sc_hd__decap_8
XTAP_TAPCELL_ROW_13_229 VGND VPWR sky130_fd_sc_hd__tapvpwrvgnd_1
XFILLER_18_89 VGND VGND VPWR VPWR sky130_fd_sc_hd__fill_2
XTAP_TAPCELL_ROW_21_284 VGND VPWR sky130_fd_sc_hd__tapvpwrvgnd_1
XFILLER_38_109 VPWR VGND VPWR VGND sky130_ef_sc_hd__decap_12
XFILLER_46_197 VPWR VGND VPWR VGND sky130_ef_sc_hd__decap_12
XFILLER_46_186 VGND VGND VPWR VPWR sky130_fd_sc_hd__decap_8
XTAP_TAPCELL_ROW_29_340 VGND VPWR sky130_fd_sc_hd__tapvpwrvgnd_1
XFILLER_19_323 VPWR VGND VPWR VGND sky130_ef_sc_hd__decap_12
XFILLER_61_167 VGND VGND VPWR VPWR sky130_fd_sc_hd__fill_1
X_0802_ net108 _0147_ VGND VGND VPWR VPWR _0043_ sky130_fd_sc_hd__and2_1
X_0733_ net73 _0100_ net62 core_out\[3\] VGND VGND VPWR VPWR _0110_ sky130_fd_sc_hd__a22o_1
X_1216_ _0533_ _0541_ VGND VGND VPWR VPWR _0543_ sky130_fd_sc_hd__xnor2_1
XFILLER_52_123 VPWR VGND VPWR VGND sky130_ef_sc_hd__decap_12
XFILLER_52_101 VGND VGND VPWR VPWR sky130_fd_sc_hd__fill_2
XFILLER_40_307 VGND VGND VPWR VPWR sky130_fd_sc_hd__fill_1
XFILLER_37_197 VGND VGND VPWR VPWR sky130_fd_sc_hd__decap_3
XTAP_TAPCELL_ROW_35_387 VGND VPWR sky130_fd_sc_hd__tapvpwrvgnd_1
X_1078_ _0407_ _0406_ _0362_ _0365_ VGND VGND VPWR VPWR _0409_ sky130_fd_sc_hd__o211a_1
XFILLER_25_337 VPWR VGND VPWR VGND sky130_ef_sc_hd__decap_12
XFILLER_25_326 VGND VGND VPWR VPWR sky130_fd_sc_hd__decap_8
XFILLER_1_81 VPWR VGND VPWR VGND sky130_ef_sc_hd__decap_12
X_1147_ _0474_ _0475_ VGND VGND VPWR VPWR _0476_ sky130_fd_sc_hd__xor2_1
Xhold22 net42 VGND VGND VPWR VPWR net138 sky130_fd_sc_hd__dlygate4sd3_1
Xhold33 net41 VGND VGND VPWR VPWR net149 sky130_fd_sc_hd__dlygate4sd3_1
Xhold66 core_out\[30\] VGND VGND VPWR VPWR net182 sky130_fd_sc_hd__dlygate4sd3_1
Xhold44 net36 VGND VGND VPWR VPWR net160 sky130_fd_sc_hd__dlygate4sd3_1
Xhold55 core_out\[2\] VGND VGND VPWR VPWR net171 sky130_fd_sc_hd__dlygate4sd3_1
XFILLER_29_77 VPWR VGND VPWR VGND sky130_ef_sc_hd__decap_12
XFILLER_28_197 VGND VGND VPWR VPWR sky130_fd_sc_hd__decap_8
XFILLER_28_153 VGND VGND VPWR VPWR sky130_fd_sc_hd__fill_1
XTAP_TAPCELL_ROW_26_321 VGND VPWR sky130_fd_sc_hd__tapvpwrvgnd_1
XFILLER_43_145 VGND VGND VPWR VPWR sky130_fd_sc_hd__decap_3
XFILLER_31_329 VGND VGND VPWR VPWR sky130_fd_sc_hd__decap_6
XFILLER_6_15 VPWR VGND VPWR VGND sky130_ef_sc_hd__decap_12
X_1001_ _0330_ _0331_ _0332_ VGND VGND VPWR VPWR _0334_ sky130_fd_sc_hd__o21ai_1
XFILLER_30_362 VGND VGND VPWR VPWR sky130_fd_sc_hd__fill_2
X_0716_ net109 _0097_ VGND VGND VPWR VPWR _0007_ sky130_fd_sc_hd__and2_1
XFILLER_40_137 VGND VGND VPWR VPWR sky130_fd_sc_hd__decap_3
XFILLER_13_329 VGND VGND VPWR VPWR sky130_fd_sc_hd__decap_6
XFILLER_15_57 VGND VGND VPWR VPWR sky130_fd_sc_hd__fill_2
XFILLER_21_373 VPWR VGND VPWR VGND sky130_ef_sc_hd__decap_12
XTAP_TAPCELL_ROW_23_302 VGND VPWR sky130_fd_sc_hd__tapvpwrvgnd_1
XFILLER_25_167 VGND VGND VPWR VPWR sky130_fd_sc_hd__fill_1
Xoutput34 net34 VGND VGND VPWR VPWR rdata[22] sky130_fd_sc_hd__buf_2
XFILLER_31_34 VPWR VGND VPWR VGND sky130_ef_sc_hd__decap_12
Xoutput23 net23 VGND VGND VPWR VPWR rdata[12] sky130_fd_sc_hd__buf_2
Xoutput45 net45 VGND VGND VPWR VPWR rdata[3] sky130_fd_sc_hd__buf_2
XFILLER_0_277 VGND VGND VPWR VPWR sky130_fd_sc_hd__decap_3
XFILLER_63_218 VGND VGND VPWR VPWR sky130_fd_sc_hd__decap_6
XFILLER_56_97 VPWR VGND VPWR VGND sky130_ef_sc_hd__decap_12
XFILLER_56_53 VPWR VGND VPWR VGND sky130_ef_sc_hd__decap_12
XFILLER_31_126 VPWR VGND VPWR VGND sky130_ef_sc_hd__decap_12
XFILLER_8_333 VPWR VGND VPWR VGND sky130_ef_sc_hd__decap_12
XFILLER_8_377 VPWR VGND VPWR VGND sky130_ef_sc_hd__decap_12
XFILLER_39_259 VGND VGND VPWR VPWR sky130_fd_sc_hd__decap_6
XFILLER_39_237 VGND VGND VPWR VPWR sky130_fd_sc_hd__decap_4
XFILLER_39_204 VPWR VGND VPWR VGND sky130_ef_sc_hd__decap_12
XFILLER_62_262 VGND VGND VPWR VPWR sky130_fd_sc_hd__decap_6
XFILLER_53_240 VGND VGND VPWR VPWR sky130_fd_sc_hd__decap_6
XFILLER_38_281 VPWR VGND VPWR VGND sky130_ef_sc_hd__decap_12
XTAP_TAPCELL_ROW_51_496 VGND VPWR sky130_fd_sc_hd__tapvpwrvgnd_1
XFILLER_42_77 VGND VGND VPWR VPWR sky130_fd_sc_hd__decap_6
XFILLER_21_181 VPWR VGND VPWR VGND sky130_ef_sc_hd__decap_12
XFILLER_3_27 VPWR VGND VPWR VGND sky130_ef_sc_hd__decap_12
XTAP_TAPCELL_ROW_59_552 VGND VPWR sky130_fd_sc_hd__tapvpwrvgnd_1
XFILLER_29_281 VGND VGND VPWR VPWR sky130_fd_sc_hd__decap_4
XTAP_TAPCELL_ROW_8_196 VGND VPWR sky130_fd_sc_hd__tapvpwrvgnd_1
XFILLER_44_284 VPWR VGND VPWR VGND sky130_ef_sc_hd__decap_12
XFILLER_44_262 VGND VGND VPWR VPWR sky130_fd_sc_hd__decap_6
X_0981_ _0261_ _0271_ _0270_ VGND VGND VPWR VPWR _0314_ sky130_fd_sc_hd__a21bo_1
XFILLER_59_3 VPWR VGND VPWR VGND sky130_ef_sc_hd__decap_12
XFILLER_12_192 VGND VGND VPWR VPWR sky130_fd_sc_hd__decap_4
X_1464_ clknet_3_3__leaf_clk _0080_ VGND VGND VPWR VPWR core_out\[31\] sky130_fd_sc_hd__dfxtp_1
X_1395_ clknet_3_2__leaf_clk _0011_ VGND VGND VPWR VPWR net42 sky130_fd_sc_hd__dfxtp_1
Xfanout109 net111 VGND VGND VPWR VPWR net109 sky130_fd_sc_hd__buf_2
XFILLER_35_273 VGND VGND VPWR VPWR sky130_fd_sc_hd__decap_6
XFILLER_27_207 VGND VGND VPWR VPWR sky130_fd_sc_hd__fill_2
XFILLER_50_276 VGND VGND VPWR VPWR sky130_fd_sc_hd__decap_3
XFILLER_50_221 VPWR VGND VPWR VGND sky130_ef_sc_hd__decap_12
XFILLER_58_365 VPWR VGND VPWR VGND sky130_ef_sc_hd__decap_12
XFILLER_58_321 VPWR VGND VPWR VGND sky130_ef_sc_hd__decap_12
XFILLER_37_33 VGND VGND VPWR VPWR sky130_fd_sc_hd__decap_8
XTAP_TAPCELL_ROW_5_177 VGND VPWR sky130_fd_sc_hd__tapvpwrvgnd_1
XTAP_TAPCELL_ROW_56_533 VGND VPWR sky130_fd_sc_hd__tapvpwrvgnd_1
XFILLER_41_221 VGND VGND VPWR VPWR sky130_fd_sc_hd__decap_3
XFILLER_26_251 VGND VGND VPWR VPWR sky130_fd_sc_hd__fill_1
XFILLER_5_111 VGND VGND VPWR VPWR sky130_fd_sc_hd__fill_1
XFILLER_1_361 VPWR VGND VPWR VGND sky130_ef_sc_hd__decap_12
XFILLER_64_335 VGND VGND VPWR VPWR sky130_fd_sc_hd__fill_1
X_1180_ _0506_ _0507_ VGND VGND VPWR VPWR _0508_ sky130_fd_sc_hd__nor2_1
XFILLER_17_251 VPWR VGND VPWR VGND sky130_ef_sc_hd__decap_12
X_0964_ net95 _0295_ _0296_ core_b\[7\] VGND VGND VPWR VPWR _0297_ sky130_fd_sc_hd__and4b_1
X_0895_ _0227_ _0228_ _0229_ VGND VGND VPWR VPWR _0230_ sky130_fd_sc_hd__or3_1
X_1378_ _0686_ net96 _0687_ net9 VGND VGND VPWR VPWR _0079_ sky130_fd_sc_hd__a211oi_2
X_1447_ clknet_3_5__leaf_clk _0063_ VGND VGND VPWR VPWR core_out\[14\] sky130_fd_sc_hd__dfxtp_1
XTAP_TAPCELL_ROW_53_514 VGND VPWR sky130_fd_sc_hd__tapvpwrvgnd_1
XFILLER_11_405 VGND VGND VPWR VPWR sky130_fd_sc_hd__fill_2
XFILLER_23_221 VGND VGND VPWR VPWR sky130_fd_sc_hd__decap_3
XFILLER_23_57 VGND VGND VPWR VPWR sky130_fd_sc_hd__fill_1
XFILLER_64_53 VGND VGND VPWR VPWR sky130_fd_sc_hd__decap_3
XFILLER_61_327 VGND VGND VPWR VPWR sky130_fd_sc_hd__decap_8
XFILLER_46_302 VGND VGND VPWR VPWR sky130_fd_sc_hd__decap_6
XFILLER_64_97 VGND VGND VPWR VPWR sky130_fd_sc_hd__decap_4
XFILLER_61_349 VPWR VGND VPWR VGND sky130_ef_sc_hd__decap_12
XFILLER_9_15 VPWR VGND VPWR VGND sky130_ef_sc_hd__decap_12
Xfanout80 core_a\[7\] VGND VGND VPWR VPWR net80 sky130_fd_sc_hd__buf_2
XFILLER_14_221 VPWR VGND VPWR VGND sky130_ef_sc_hd__decap_12
XFILLER_14_265 VPWR VGND VPWR VGND sky130_ef_sc_hd__decap_12
XTAP_TAPCELL_ROW_16_249 VGND VPWR sky130_fd_sc_hd__tapvpwrvgnd_1
Xfanout91 core_a\[2\] VGND VGND VPWR VPWR net91 sky130_fd_sc_hd__buf_2
XFILLER_13_90 VGND VGND VPWR VPWR sky130_fd_sc_hd__decap_6
X_1301_ core_out\[19\] core_out\[18\] core_out\[17\] core_out\[16\] net123 VGND VGND
+ VPWR VPWR _0621_ sky130_fd_sc_hd__o41a_1
X_1232_ net98 core_out\[13\] net116 _0558_ VGND VGND VPWR VPWR _0062_ sky130_fd_sc_hd__o211a_1
XFILLER_52_338 VGND VGND VPWR VPWR sky130_fd_sc_hd__fill_2
XFILLER_37_357 VPWR VGND VPWR VGND sky130_ef_sc_hd__decap_12
XFILLER_37_335 VGND VGND VPWR VPWR sky130_fd_sc_hd__fill_1
X_1163_ core_out\[11\] _0491_ VGND VGND VPWR VPWR _0492_ sky130_fd_sc_hd__and2_1
X_1094_ net69 net86 _0392_ _0391_ VGND VGND VPWR VPWR _0424_ sky130_fd_sc_hd__a31o_1
X_0947_ _0277_ _0279_ _0238_ _0240_ VGND VGND VPWR VPWR _0281_ sky130_fd_sc_hd__o211a_1
XFILLER_20_279 VGND VGND VPWR VPWR sky130_fd_sc_hd__fill_2
X_0878_ _0211_ _0212_ _0188_ VGND VGND VPWR VPWR _0214_ sky130_fd_sc_hd__o21bai_1
XFILLER_50_55 VGND VGND VPWR VPWR sky130_fd_sc_hd__fill_1
Xclkload0 clknet_3_0__leaf_clk VGND VGND VPWR VPWR clkload0/Y sky130_fd_sc_hd__clkinv_4
XFILLER_11_279 VGND VGND VPWR VPWR sky130_fd_sc_hd__fill_1
XTAP_TAPCELL_ROW_21_285 VGND VPWR sky130_fd_sc_hd__tapvpwrvgnd_1
XFILLER_61_113 VPWR VGND VPWR VGND sky130_ef_sc_hd__decap_12
XFILLER_34_338 VGND VGND VPWR VPWR sky130_fd_sc_hd__fill_1
XTAP_TAPCELL_ROW_29_341 VGND VPWR sky130_fd_sc_hd__tapvpwrvgnd_1
XFILLER_19_335 VGND VGND VPWR VPWR sky130_fd_sc_hd__fill_1
X_0801_ net74 net13 _0144_ VGND VGND VPWR VPWR _0147_ sky130_fd_sc_hd__mux2_1
XFILLER_41_3 VGND VGND VPWR VPWR sky130_fd_sc_hd__decap_8
X_0732_ net138 net107 _0109_ net110 VGND VGND VPWR VPWR _0011_ sky130_fd_sc_hd__o211a_1
X_1215_ _0531_ _0532_ _0541_ VGND VGND VPWR VPWR _0542_ sky130_fd_sc_hd__nor3_1
X_1146_ net68 net83 VGND VGND VPWR VPWR _0475_ sky130_fd_sc_hd__nand2_1
XFILLER_52_135 VGND VGND VPWR VPWR sky130_fd_sc_hd__decap_4
XTAP_TAPCELL_ROW_35_388 VGND VPWR sky130_fd_sc_hd__tapvpwrvgnd_1
XFILLER_33_393 VGND VGND VPWR VPWR sky130_fd_sc_hd__decap_4
X_1077_ _0362_ _0365_ _0406_ _0407_ VGND VGND VPWR VPWR _0408_ sky130_fd_sc_hd__a211oi_4
XFILLER_25_349 VPWR VGND VPWR VGND sky130_ef_sc_hd__decap_12
XFILLER_1_93 VPWR VGND VPWR VGND sky130_ef_sc_hd__decap_12
XFILLER_4_209 VPWR VGND VPWR VGND sky130_ef_sc_hd__decap_12
XFILLER_20_36 VPWR VGND VPWR VGND sky130_ef_sc_hd__decap_12
Xhold34 net50 VGND VGND VPWR VPWR net150 sky130_fd_sc_hd__dlygate4sd3_1
Xhold45 net39 VGND VGND VPWR VPWR net161 sky130_fd_sc_hd__dlygate4sd3_1
Xhold56 core_out\[3\] VGND VGND VPWR VPWR net172 sky130_fd_sc_hd__dlygate4sd3_1
Xhold23 net47 VGND VGND VPWR VPWR net139 sky130_fd_sc_hd__dlygate4sd3_1
Xhold67 core_out\[29\] VGND VGND VPWR VPWR net183 sky130_fd_sc_hd__dlygate4sd3_1
XFILLER_45_44 VGND VGND VPWR VPWR sky130_fd_sc_hd__decap_8
XFILLER_43_124 VGND VGND VPWR VPWR sky130_fd_sc_hd__decap_6
XFILLER_43_113 VGND VGND VPWR VPWR sky130_fd_sc_hd__decap_3
XFILLER_29_89 VGND VGND VPWR VPWR sky130_fd_sc_hd__decap_6
XFILLER_28_187 VGND VGND VPWR VPWR sky130_fd_sc_hd__decap_8
XTAP_TAPCELL_ROW_26_322 VGND VPWR sky130_fd_sc_hd__tapvpwrvgnd_1
XFILLER_24_360 VGND VGND VPWR VPWR sky130_fd_sc_hd__decap_4
XFILLER_6_27 VGND VGND VPWR VPWR sky130_fd_sc_hd__fill_1
X_1000_ _0330_ _0331_ _0332_ VGND VGND VPWR VPWR _0333_ sky130_fd_sc_hd__or3_1
XFILLER_19_110 VGND VGND VPWR VPWR sky130_fd_sc_hd__fill_2
XFILLER_15_393 VPWR VGND VPWR VGND sky130_ef_sc_hd__decap_12
X_0715_ net82 net17 _0090_ VGND VGND VPWR VPWR _0097_ sky130_fd_sc_hd__mux2_1
X_1129_ core_out\[10\] _0458_ VGND VGND VPWR VPWR _0459_ sky130_fd_sc_hd__nand2_1
XFILLER_25_113 VPWR VGND VPWR VGND sky130_ef_sc_hd__decap_12
XFILLER_21_385 VGND VGND VPWR VPWR sky130_fd_sc_hd__decap_6
XTAP_TAPCELL_ROW_23_303 VGND VPWR sky130_fd_sc_hd__tapvpwrvgnd_1
Xoutput35 net35 VGND VGND VPWR VPWR rdata[23] sky130_fd_sc_hd__buf_2
Xoutput46 net46 VGND VGND VPWR VPWR rdata[4] sky130_fd_sc_hd__buf_2
XFILLER_31_57 VPWR VGND VPWR VGND sky130_ef_sc_hd__decap_12
XFILLER_31_46 VGND VGND VPWR VPWR sky130_fd_sc_hd__decap_8
Xoutput24 net24 VGND VGND VPWR VPWR rdata[13] sky130_fd_sc_hd__buf_2
XFILLER_56_65 VPWR VGND VPWR VGND sky130_ef_sc_hd__decap_12
XFILLER_31_138 VPWR VGND VPWR VGND sky130_ef_sc_hd__decap_12
XFILLER_16_102 VGND VGND VPWR VPWR sky130_fd_sc_hd__fill_1
XFILLER_16_179 VGND VGND VPWR VPWR sky130_fd_sc_hd__fill_1
XPHY_EDGE_ROW_19_Right_19 VGND VGND VPWR VPWR sky130_fd_sc_hd__decap_3
XFILLER_8_301 VGND VGND VPWR VPWR sky130_fd_sc_hd__decap_6
XFILLER_8_345 VPWR VGND VPWR VGND sky130_ef_sc_hd__decap_12
XFILLER_8_389 VPWR VGND VPWR VGND sky130_ef_sc_hd__decap_12
XFILLER_12_363 VGND VGND VPWR VPWR sky130_fd_sc_hd__fill_1
Xclkbuf_3_1__f_clk clknet_0_clk VGND VGND VPWR VPWR clknet_3_1__leaf_clk sky130_fd_sc_hd__clkbuf_16
XFILLER_39_216 VGND VGND VPWR VPWR sky130_fd_sc_hd__decap_8
XPHY_EDGE_ROW_28_Right_28 VGND VGND VPWR VPWR sky130_fd_sc_hd__decap_3
XPHY_EDGE_ROW_37_Right_37 VGND VGND VPWR VPWR sky130_fd_sc_hd__decap_3
XPHY_EDGE_ROW_46_Right_46 VGND VGND VPWR VPWR sky130_fd_sc_hd__decap_3
XPHY_EDGE_ROW_55_Right_55 VGND VGND VPWR VPWR sky130_fd_sc_hd__decap_3
XFILLER_38_293 VPWR VGND VPWR VGND sky130_ef_sc_hd__decap_12
XPHY_EDGE_ROW_64_Right_64 VGND VGND VPWR VPWR sky130_fd_sc_hd__decap_3
XTAP_TAPCELL_ROW_51_497 VGND VPWR sky130_fd_sc_hd__tapvpwrvgnd_1
XPHY_EDGE_ROW_39_Left_104 VGND VGND VPWR VPWR sky130_fd_sc_hd__decap_3
XFILLER_5_337 VPWR VGND VPWR VGND sky130_ef_sc_hd__decap_12
XFILLER_21_193 VGND VGND VPWR VPWR sky130_fd_sc_hd__decap_4
XFILLER_3_39 VPWR VGND VPWR VGND sky130_ef_sc_hd__decap_12
XTAP_TAPCELL_ROW_59_553 VGND VPWR sky130_fd_sc_hd__tapvpwrvgnd_1
XPHY_EDGE_ROW_48_Left_113 VGND VGND VPWR VPWR sky130_fd_sc_hd__decap_3
XFILLER_29_293 VGND VGND VPWR VPWR sky130_fd_sc_hd__fill_2
XTAP_TAPCELL_ROW_8_197 VGND VPWR sky130_fd_sc_hd__tapvpwrvgnd_1
XFILLER_44_296 VPWR VGND VPWR VGND sky130_ef_sc_hd__decap_12
XTAP_TAPCELL_ROW_42_431 VGND VPWR sky130_fd_sc_hd__tapvpwrvgnd_1
X_0980_ _0310_ _0311_ _0305_ VGND VGND VPWR VPWR _0313_ sky130_fd_sc_hd__a21o_1
XPHY_EDGE_ROW_57_Left_122 VGND VGND VPWR VPWR sky130_fd_sc_hd__decap_3
XFILLER_8_131 VGND VGND VPWR VPWR sky130_fd_sc_hd__fill_1
XFILLER_8_186 VGND VGND VPWR VPWR sky130_fd_sc_hd__decap_8
XFILLER_8_197 VGND VGND VPWR VPWR sky130_fd_sc_hd__decap_6
X_1463_ clknet_3_6__leaf_clk _0079_ VGND VGND VPWR VPWR core_out\[30\] sky130_fd_sc_hd__dfxtp_1
X_1394_ clknet_3_0__leaf_clk _0010_ VGND VGND VPWR VPWR net31 sky130_fd_sc_hd__dfxtp_1
XFILLER_50_233 VPWR VGND VPWR VGND sky130_ef_sc_hd__decap_12
XFILLER_12_15 VPWR VGND VPWR VGND sky130_ef_sc_hd__decap_12
XFILLER_2_307 VGND VGND VPWR VPWR sky130_fd_sc_hd__fill_1
XFILLER_58_377 VPWR VGND VPWR VGND sky130_ef_sc_hd__decap_12
XFILLER_58_333 VPWR VGND VPWR VGND sky130_ef_sc_hd__decap_12
XTAP_TAPCELL_ROW_56_534 VGND VPWR sky130_fd_sc_hd__tapvpwrvgnd_1
XTAP_TAPCELL_ROW_5_178 VGND VPWR sky130_fd_sc_hd__tapvpwrvgnd_1
XFILLER_5_167 VGND VGND VPWR VPWR sky130_fd_sc_hd__fill_1
XFILLER_1_373 VPWR VGND VPWR VGND sky130_ef_sc_hd__decap_12
XFILLER_64_303 VGND VGND VPWR VPWR sky130_fd_sc_hd__decap_4
XFILLER_17_263 VPWR VGND VPWR VGND sky130_ef_sc_hd__decap_12
X_0894_ net78 net85 net87 net77 VGND VGND VPWR VPWR _0229_ sky130_fd_sc_hd__a22oi_2
XFILLER_32_266 VGND VGND VPWR VPWR sky130_fd_sc_hd__decap_8
X_0963_ net69 net90 net93 net67 VGND VGND VPWR VPWR _0296_ sky130_fd_sc_hd__a22o_1
X_1377_ net96 net182 VGND VGND VPWR VPWR _0687_ sky130_fd_sc_hd__nor2_1
X_1446_ clknet_3_5__leaf_clk _0062_ VGND VGND VPWR VPWR core_out\[13\] sky130_fd_sc_hd__dfxtp_1
XFILLER_63_391 VGND VGND VPWR VPWR sky130_fd_sc_hd__fill_1
XTAP_TAPCELL_ROW_61_570 VGND VPWR sky130_fd_sc_hd__tapvpwrvgnd_1
XFILLER_23_277 VGND VGND VPWR VPWR sky130_fd_sc_hd__decap_3
XFILLER_58_141 VGND VGND VPWR VPWR sky130_fd_sc_hd__decap_8
XFILLER_58_185 VGND VGND VPWR VPWR sky130_fd_sc_hd__decap_8
XFILLER_0_29 VPWR VGND VPWR VGND sky130_ef_sc_hd__decap_12
XFILLER_9_27 VPWR VGND VPWR VGND sky130_ef_sc_hd__decap_12
XFILLER_14_233 VPWR VGND VPWR VGND sky130_ef_sc_hd__decap_12
XFILLER_14_277 VPWR VGND VPWR VGND sky130_ef_sc_hd__decap_12
Xfanout70 core_b\[4\] VGND VGND VPWR VPWR net70 sky130_fd_sc_hd__buf_2
Xfanout81 core_a\[7\] VGND VGND VPWR VPWR net81 sky130_fd_sc_hd__buf_6
Xfanout92 core_a\[1\] VGND VGND VPWR VPWR net92 sky130_fd_sc_hd__buf_2
XPHY_EDGE_ROW_24_Left_89 VGND VGND VPWR VPWR sky130_fd_sc_hd__decap_3
XFILLER_49_152 VPWR VGND VPWR VGND sky130_ef_sc_hd__decap_12
X_1300_ _0580_ _0582_ _0598_ _0619_ _0599_ VGND VGND VPWR VPWR _0620_ sky130_fd_sc_hd__a311o_1
X_1231_ net98 _0557_ VGND VGND VPWR VPWR _0558_ sky130_fd_sc_hd__nand2_1
X_1162_ _0489_ _0490_ VGND VGND VPWR VPWR _0491_ sky130_fd_sc_hd__xnor2_1
XFILLER_1_181 VPWR VGND VPWR VGND sky130_ef_sc_hd__decap_12
XFILLER_52_328 VGND VGND VPWR VPWR sky130_fd_sc_hd__fill_2
XFILLER_37_369 VPWR VGND VPWR VGND sky130_ef_sc_hd__decap_12
X_1093_ _0340_ _0388_ _0387_ VGND VGND VPWR VPWR _0423_ sky130_fd_sc_hd__a21oi_1
X_0877_ _0211_ _0212_ _0188_ VGND VGND VPWR VPWR _0213_ sky130_fd_sc_hd__or3b_2
X_0946_ _0238_ _0240_ _0277_ _0279_ VGND VGND VPWR VPWR _0280_ sky130_fd_sc_hd__a211oi_2
XFILLER_9_281 VPWR VGND VPWR VGND sky130_ef_sc_hd__decap_12
X_1429_ clknet_3_1__leaf_clk _0045_ VGND VGND VPWR VPWR core_b\[4\] sky130_fd_sc_hd__dfxtp_1
XFILLER_55_111 VGND VGND VPWR VPWR sky130_fd_sc_hd__fill_1
XFILLER_51_361 VPWR VGND VPWR VGND sky130_ef_sc_hd__decap_12
XFILLER_11_214 VGND VGND VPWR VPWR sky130_fd_sc_hd__decap_8
XFILLER_11_225 VPWR VGND VPWR VGND sky130_ef_sc_hd__decap_12
Xclkload1 clknet_3_1__leaf_clk VGND VGND VPWR VPWR clkload1/X sky130_fd_sc_hd__clkbuf_8
XFILLER_50_89 VGND VGND VPWR VPWR sky130_fd_sc_hd__fill_1
XFILLER_1_3 VPWR VGND VPWR VGND sky130_ef_sc_hd__decap_12
XTAP_TAPCELL_ROW_21_286 VGND VPWR sky130_fd_sc_hd__tapvpwrvgnd_1
XFILLER_61_169 VGND VGND VPWR VPWR sky130_fd_sc_hd__decap_8
XFILLER_61_125 VPWR VGND VPWR VGND sky130_ef_sc_hd__decap_12
XFILLER_34_317 VGND VGND VPWR VPWR sky130_fd_sc_hd__fill_2
XTAP_TAPCELL_ROW_29_342 VGND VPWR sky130_fd_sc_hd__tapvpwrvgnd_1
X_0731_ core_out\[2\] net62 _0108_ _0102_ VGND VGND VPWR VPWR _0109_ sky130_fd_sc_hd__a211o_1
XFILLER_6_251 VGND VGND VPWR VPWR sky130_fd_sc_hd__fill_1
X_0800_ net109 _0146_ VGND VGND VPWR VPWR _0042_ sky130_fd_sc_hd__and2_1
XFILLER_34_3 VGND VGND VPWR VPWR sky130_fd_sc_hd__decap_8
XFILLER_37_177 VPWR VGND VPWR VGND sky130_ef_sc_hd__decap_12
X_1214_ _0507_ _0539_ VGND VGND VPWR VPWR _0541_ sky130_fd_sc_hd__xnor2_1
X_1145_ _0435_ _0473_ VGND VGND VPWR VPWR _0474_ sky130_fd_sc_hd__and2_1
XFILLER_40_309 VGND VGND VPWR VPWR sky130_fd_sc_hd__decap_6
XFILLER_33_361 VPWR VGND VPWR VGND sky130_ef_sc_hd__decap_12
X_1076_ _0404_ _0405_ _0389_ VGND VGND VPWR VPWR _0407_ sky130_fd_sc_hd__a21oi_1
X_0929_ net77 net83 VGND VGND VPWR VPWR _0263_ sky130_fd_sc_hd__nand2_1
XFILLER_20_15 VPWR VGND VPWR VGND sky130_ef_sc_hd__decap_12
XFILLER_20_48 VPWR VGND VPWR VGND sky130_ef_sc_hd__decap_12
Xhold35 net38 VGND VGND VPWR VPWR net151 sky130_fd_sc_hd__dlygate4sd3_1
Xhold57 core_out\[28\] VGND VGND VPWR VPWR net173 sky130_fd_sc_hd__dlygate4sd3_1
Xhold24 net46 VGND VGND VPWR VPWR net140 sky130_fd_sc_hd__dlygate4sd3_1
Xhold68 core_out\[27\] VGND VGND VPWR VPWR net184 sky130_fd_sc_hd__dlygate4sd3_1
XFILLER_29_57 VGND VGND VPWR VPWR sky130_fd_sc_hd__decap_4
XFILLER_29_46 VGND VGND VPWR VPWR sky130_fd_sc_hd__decap_4
XFILLER_29_24 VGND VGND VPWR VPWR sky130_fd_sc_hd__decap_8
Xhold46 net23 VGND VGND VPWR VPWR net162 sky130_fd_sc_hd__dlygate4sd3_1
XFILLER_0_405 VGND VGND VPWR VPWR sky130_fd_sc_hd__fill_2
XFILLER_45_78 VGND VGND VPWR VPWR sky130_fd_sc_hd__fill_2
XFILLER_43_169 VGND VGND VPWR VPWR sky130_fd_sc_hd__decap_6
XTAP_TAPCELL_ROW_26_323 VGND VPWR sky130_fd_sc_hd__tapvpwrvgnd_1
XFILLER_61_55 VGND VGND VPWR VPWR sky130_fd_sc_hd__fill_1
XFILLER_62_401 VGND VGND VPWR VPWR sky130_fd_sc_hd__decap_6
XFILLER_15_361 VPWR VGND VPWR VGND sky130_ef_sc_hd__decap_12
XFILLER_22_309 VPWR VGND VPWR VGND sky130_ef_sc_hd__decap_12
XFILLER_30_386 VGND VGND VPWR VPWR sky130_fd_sc_hd__fill_2
X_0714_ net108 _0096_ VGND VGND VPWR VPWR _0006_ sky130_fd_sc_hd__and2_1
XPHY_EDGE_ROW_27_Left_92 VGND VGND VPWR VPWR sky130_fd_sc_hd__decap_3
X_1128_ _0454_ _0457_ VGND VGND VPWR VPWR _0458_ sky130_fd_sc_hd__xnor2_1
XPHY_EDGE_ROW_11_Left_76 VGND VGND VPWR VPWR sky130_fd_sc_hd__decap_3
X_1059_ net68 net86 VGND VGND VPWR VPWR _0390_ sky130_fd_sc_hd__nand2_1
XTAP_TAPCELL_ROW_23_304 VGND VPWR sky130_fd_sc_hd__tapvpwrvgnd_1
XFILLER_25_125 VGND VGND VPWR VPWR sky130_fd_sc_hd__decap_8
XFILLER_25_158 VGND VGND VPWR VPWR sky130_fd_sc_hd__fill_1
Xoutput36 net36 VGND VGND VPWR VPWR rdata[24] sky130_fd_sc_hd__buf_2
Xoutput47 net47 VGND VGND VPWR VPWR rdata[5] sky130_fd_sc_hd__buf_2
XFILLER_31_69 VGND VGND VPWR VPWR sky130_fd_sc_hd__decap_8
Xoutput25 net25 VGND VGND VPWR VPWR rdata[14] sky130_fd_sc_hd__buf_2
XFILLER_56_77 VGND VGND VPWR VPWR sky130_fd_sc_hd__decap_6
XFILLER_8_357 VGND VGND VPWR VPWR sky130_fd_sc_hd__decap_6
XFILLER_21_91 VGND VGND VPWR VPWR sky130_fd_sc_hd__decap_4
XFILLER_47_261 VGND VGND VPWR VPWR sky130_fd_sc_hd__decap_4
XFILLER_30_194 VGND VGND VPWR VPWR sky130_fd_sc_hd__fill_2
XFILLER_22_139 VGND VGND VPWR VPWR sky130_fd_sc_hd__fill_1
XFILLER_38_261 VGND VGND VPWR VPWR sky130_fd_sc_hd__fill_2
XFILLER_13_128 VPWR VGND VPWR VGND sky130_ef_sc_hd__decap_12
XTAP_TAPCELL_ROW_51_498 VGND VPWR sky130_fd_sc_hd__tapvpwrvgnd_1
XFILLER_42_57 VGND VGND VPWR VPWR sky130_fd_sc_hd__fill_1
XFILLER_5_349 VPWR VGND VPWR VGND sky130_ef_sc_hd__decap_12
XFILLER_5_305 VPWR VGND VPWR VGND sky130_ef_sc_hd__decap_12
XTAP_TAPCELL_ROW_8_198 VGND VPWR sky130_fd_sc_hd__tapvpwrvgnd_1
XTAP_TAPCELL_ROW_59_554 VGND VPWR sky130_fd_sc_hd__tapvpwrvgnd_1
XTAP_TAPCELL_ROW_42_432 VGND VPWR sky130_fd_sc_hd__tapvpwrvgnd_1
XFILLER_12_161 VPWR VGND VPWR VGND sky130_ef_sc_hd__decap_12
X_1462_ clknet_3_6__leaf_clk _0078_ VGND VGND VPWR VPWR core_out\[29\] sky130_fd_sc_hd__dfxtp_1
X_1393_ clknet_3_0__leaf_clk _0009_ VGND VGND VPWR VPWR net20 sky130_fd_sc_hd__dfxtp_1
XFILLER_50_245 VGND VGND VPWR VPWR sky130_fd_sc_hd__decap_6
XFILLER_10_109 VPWR VGND VPWR VGND sky130_ef_sc_hd__decap_12
XFILLER_12_27 VGND VGND VPWR VPWR sky130_fd_sc_hd__fill_1
XFILLER_58_389 VPWR VGND VPWR VGND sky130_ef_sc_hd__decap_12
XFILLER_58_345 VPWR VGND VPWR VGND sky130_ef_sc_hd__decap_12
XTAP_TAPCELL_ROW_56_535 VGND VPWR sky130_fd_sc_hd__tapvpwrvgnd_1
XFILLER_37_79 VGND VGND VPWR VPWR sky130_fd_sc_hd__fill_1
XFILLER_37_57 VGND VGND VPWR VPWR sky130_fd_sc_hd__decap_3
XFILLER_26_253 VGND VGND VPWR VPWR sky130_fd_sc_hd__decap_4
XTAP_TAPCELL_ROW_64_590 VGND VPWR sky130_fd_sc_hd__tapvpwrvgnd_1
XFILLER_53_12 VPWR VGND VPWR VGND sky130_ef_sc_hd__decap_12
XFILLER_41_289 VGND VGND VPWR VPWR sky130_fd_sc_hd__decap_4
XFILLER_41_201 VGND VGND VPWR VPWR sky130_fd_sc_hd__fill_2
XFILLER_5_113 VPWR VGND VPWR VGND sky130_ef_sc_hd__decap_12
XFILLER_64_315 VPWR VGND VPWR VGND sky130_ef_sc_hd__decap_12
XFILLER_49_312 VGND VGND VPWR VPWR sky130_fd_sc_hd__decap_6
XFILLER_1_385 VGND VGND VPWR VPWR sky130_fd_sc_hd__decap_6
XFILLER_64_337 VPWR VGND VPWR VGND sky130_ef_sc_hd__decap_12
XFILLER_32_223 VGND VGND VPWR VPWR sky130_fd_sc_hd__decap_8
XFILLER_17_231 VGND VGND VPWR VPWR sky130_fd_sc_hd__fill_1
XFILLER_17_275 VGND VGND VPWR VPWR sky130_fd_sc_hd__decap_4
XFILLER_64_3 VPWR VGND VPWR VGND sky130_ef_sc_hd__decap_12
X_0893_ net77 net78 net85 net87 VGND VGND VPWR VPWR _0228_ sky130_fd_sc_hd__and4_1
X_0962_ _0294_ VGND VGND VPWR VPWR _0295_ sky130_fd_sc_hd__inv_2
XFILLER_4_83 VGND VGND VPWR VPWR sky130_fd_sc_hd__fill_1
X_1445_ clknet_3_5__leaf_clk _0061_ VGND VGND VPWR VPWR core_out\[12\] sky130_fd_sc_hd__dfxtp_1
X_1376_ _0684_ _0685_ VGND VGND VPWR VPWR _0686_ sky130_fd_sc_hd__or2_4
XFILLER_55_337 VPWR VGND VPWR VGND sky130_ef_sc_hd__decap_12
XFILLER_23_15 VPWR VGND VPWR VGND sky130_ef_sc_hd__decap_12
XFILLER_58_120 VPWR VGND VPWR VGND sky130_ef_sc_hd__decap_12
XFILLER_14_245 VGND VGND VPWR VPWR sky130_fd_sc_hd__decap_6
Xfanout60 net61 VGND VGND VPWR VPWR net60 sky130_fd_sc_hd__buf_2
Xfanout71 core_b\[4\] VGND VGND VPWR VPWR net71 sky130_fd_sc_hd__clkbuf_2
Xfanout93 core_a\[1\] VGND VGND VPWR VPWR net93 sky130_fd_sc_hd__clkbuf_2
XFILLER_9_39 VPWR VGND VPWR VGND sky130_ef_sc_hd__decap_12
Xfanout82 net83 VGND VGND VPWR VPWR net82 sky130_fd_sc_hd__clkbuf_2
XFILLER_14_289 VPWR VGND VPWR VGND sky130_ef_sc_hd__decap_12
XFILLER_64_167 VGND VGND VPWR VPWR sky130_fd_sc_hd__fill_1
XFILLER_49_164 VGND VGND VPWR VPWR sky130_fd_sc_hd__decap_4
XFILLER_49_120 VPWR VGND VPWR VGND sky130_ef_sc_hd__decap_12
X_1092_ net99 net168 net112 _0422_ VGND VGND VPWR VPWR _0058_ sky130_fd_sc_hd__o211a_1
X_1161_ _0451_ _0457_ _0452_ VGND VGND VPWR VPWR _0490_ sky130_fd_sc_hd__a21o_1
X_1230_ net134 _0556_ VGND VGND VPWR VPWR _0557_ sky130_fd_sc_hd__xnor2_1
XFILLER_1_193 VPWR VGND VPWR VGND sky130_ef_sc_hd__decap_12
XFILLER_64_189 VGND VGND VPWR VPWR sky130_fd_sc_hd__decap_6
XFILLER_20_204 VPWR VGND VPWR VGND sky130_ef_sc_hd__decap_12
X_0876_ _0208_ _0209_ _0210_ VGND VGND VPWR VPWR _0212_ sky130_fd_sc_hd__a21oi_1
X_0945_ _0275_ _0276_ _0255_ VGND VGND VPWR VPWR _0279_ sky130_fd_sc_hd__a21oi_1
XFILLER_9_293 VPWR VGND VPWR VGND sky130_ef_sc_hd__decap_12
X_1428_ clknet_3_0__leaf_clk _0044_ VGND VGND VPWR VPWR core_b\[3\] sky130_fd_sc_hd__dfxtp_2
XFILLER_18_15 VGND VGND VPWR VPWR sky130_fd_sc_hd__decap_6
XFILLER_18_26 VGND VGND VPWR VPWR sky130_fd_sc_hd__fill_2
X_1359_ _0670_ VGND VGND VPWR VPWR _0671_ sky130_fd_sc_hd__inv_2
XFILLER_51_373 VPWR VGND VPWR VGND sky130_ef_sc_hd__decap_12
XFILLER_50_24 VGND VGND VPWR VPWR sky130_fd_sc_hd__decap_4
Xclkload2 clknet_3_2__leaf_clk VGND VGND VPWR VPWR clkload2/Y sky130_fd_sc_hd__clkinv_4
XFILLER_11_237 VGND VGND VPWR VPWR sky130_fd_sc_hd__decap_4
XTAP_TAPCELL_ROW_21_287 VGND VPWR sky130_fd_sc_hd__tapvpwrvgnd_1
XFILLER_59_55 VGND VGND VPWR VPWR sky130_fd_sc_hd__fill_1
XFILLER_46_145 VGND VGND VPWR VPWR sky130_fd_sc_hd__fill_1
XFILLER_46_112 VPWR VGND VPWR VGND sky130_ef_sc_hd__decap_12
XFILLER_34_307 VGND VGND VPWR VPWR sky130_fd_sc_hd__fill_1
XTAP_TAPCELL_ROW_29_343 VGND VPWR sky130_fd_sc_hd__tapvpwrvgnd_1
XFILLER_19_337 VPWR VGND VPWR VGND sky130_ef_sc_hd__decap_12
XFILLER_61_137 VPWR VGND VPWR VGND sky130_ef_sc_hd__decap_12
X_0730_ net91 net64 _0100_ net75 VGND VGND VPWR VPWR _0108_ sky130_fd_sc_hd__a22o_1
XTAP_TAPCELL_ROW_12_221 VGND VPWR sky130_fd_sc_hd__tapvpwrvgnd_1
X_1213_ _0507_ _0539_ VGND VGND VPWR VPWR _0540_ sky130_fd_sc_hd__and2_1
XFILLER_37_189 VGND VGND VPWR VPWR sky130_fd_sc_hd__decap_8
XFILLER_1_51 VGND VGND VPWR VPWR sky130_fd_sc_hd__decap_4
X_1144_ net70 net72 net80 VGND VGND VPWR VPWR _0473_ sky130_fd_sc_hd__o21a_1
X_1075_ _0389_ _0404_ _0405_ VGND VGND VPWR VPWR _0406_ sky130_fd_sc_hd__and3_4
X_0859_ net96 _0195_ VGND VGND VPWR VPWR _0196_ sky130_fd_sc_hd__nand2_1
X_0928_ net75 net87 VGND VGND VPWR VPWR _0262_ sky130_fd_sc_hd__nand2_1
XFILLER_20_27 VGND VGND VPWR VPWR sky130_fd_sc_hd__fill_1
Xhold47 net43 VGND VGND VPWR VPWR net163 sky130_fd_sc_hd__dlygate4sd3_1
Xhold58 core_out\[26\] VGND VGND VPWR VPWR net174 sky130_fd_sc_hd__dlygate4sd3_1
Xhold69 core_out\[31\] VGND VGND VPWR VPWR net185 sky130_fd_sc_hd__dlygate4sd3_1
Xhold25 net32 VGND VGND VPWR VPWR net141 sky130_fd_sc_hd__dlygate4sd3_1
Xhold36 net24 VGND VGND VPWR VPWR net152 sky130_fd_sc_hd__dlygate4sd3_1
XFILLER_28_167 VPWR VGND VPWR VGND sky130_ef_sc_hd__decap_12
XTAP_TAPCELL_ROW_26_324 VGND VPWR sky130_fd_sc_hd__tapvpwrvgnd_1
XFILLER_6_29 VPWR VGND VPWR VGND sky130_ef_sc_hd__decap_12
XFILLER_59_281 VGND VGND VPWR VPWR sky130_fd_sc_hd__decap_8
XFILLER_34_104 VPWR VGND VPWR VGND sky130_ef_sc_hd__decap_12
XFILLER_19_167 VGND VGND VPWR VPWR sky130_fd_sc_hd__fill_1
XFILLER_30_365 VGND VGND VPWR VPWR sky130_fd_sc_hd__decap_4
XFILLER_30_332 VPWR VGND VPWR VGND sky130_ef_sc_hd__decap_12
XFILLER_15_373 VPWR VGND VPWR VGND sky130_ef_sc_hd__decap_12
X_0713_ net84 net16 _0090_ VGND VGND VPWR VPWR _0096_ sky130_fd_sc_hd__mux2_1
X_1127_ _0336_ _0455_ _0456_ VGND VGND VPWR VPWR _0457_ sky130_fd_sc_hd__a21o_1
XFILLER_33_181 VGND VGND VPWR VPWR sky130_fd_sc_hd__decap_4
XFILLER_15_49 VGND VGND VPWR VPWR sky130_fd_sc_hd__decap_6
X_1058_ _0340_ _0388_ VGND VGND VPWR VPWR _0389_ sky130_fd_sc_hd__xor2_1
XTAP_TAPCELL_ROW_31_360 VGND VPWR sky130_fd_sc_hd__tapvpwrvgnd_1
Xoutput37 net37 VGND VGND VPWR VPWR rdata[25] sky130_fd_sc_hd__buf_2
Xoutput48 net48 VGND VGND VPWR VPWR rdata[6] sky130_fd_sc_hd__buf_2
Xoutput26 net26 VGND VGND VPWR VPWR rdata[15] sky130_fd_sc_hd__buf_2
XPHY_EDGE_ROW_1_Right_1 VGND VGND VPWR VPWR sky130_fd_sc_hd__decap_3
XFILLER_0_225 VPWR VGND VPWR VGND sky130_ef_sc_hd__decap_12
XFILLER_48_218 VGND VGND VPWR VPWR sky130_fd_sc_hd__decap_6
XFILLER_12_321 VPWR VGND VPWR VGND sky130_ef_sc_hd__decap_12
XFILLER_12_365 VPWR VGND VPWR VGND sky130_ef_sc_hd__decap_12
XFILLER_11_6 VPWR VGND VPWR VGND sky130_ef_sc_hd__decap_12
XTAP_TAPCELL_ROW_45_452 VGND VPWR sky130_fd_sc_hd__tapvpwrvgnd_1
XFILLER_35_402 VGND VGND VPWR VPWR sky130_fd_sc_hd__decap_4
XFILLER_7_391 VGND VGND VPWR VPWR sky130_fd_sc_hd__fill_1
XFILLER_38_251 VGND VGND VPWR VPWR sky130_fd_sc_hd__fill_1
XFILLER_42_69 VGND VGND VPWR VPWR sky130_fd_sc_hd__fill_1
XTAP_TAPCELL_ROW_51_499 VGND VPWR sky130_fd_sc_hd__tapvpwrvgnd_1
XFILLER_5_317 VPWR VGND VPWR VGND sky130_ef_sc_hd__decap_12
XTAP_TAPCELL_ROW_59_555 VGND VPWR sky130_fd_sc_hd__tapvpwrvgnd_1
XTAP_TAPCELL_ROW_8_199 VGND VPWR sky130_fd_sc_hd__tapvpwrvgnd_1
XFILLER_29_273 VGND VGND VPWR VPWR sky130_fd_sc_hd__decap_6
XTAP_TAPCELL_ROW_42_433 VGND VPWR sky130_fd_sc_hd__tapvpwrvgnd_1
XFILLER_12_173 VGND VGND VPWR VPWR sky130_fd_sc_hd__decap_4
X_1461_ clknet_3_6__leaf_clk _0077_ VGND VGND VPWR VPWR core_out\[28\] sky130_fd_sc_hd__dfxtp_1
X_1392_ clknet_3_1__leaf_clk _0008_ VGND VGND VPWR VPWR core_a\[7\] sky130_fd_sc_hd__dfxtp_2
XFILLER_23_405 VGND VGND VPWR VPWR sky130_fd_sc_hd__fill_2
XFILLER_2_309 VPWR VGND VPWR VGND sky130_ef_sc_hd__decap_12
XFILLER_58_357 VGND VGND VPWR VPWR sky130_fd_sc_hd__decap_6
XFILLER_53_24 VPWR VGND VPWR VGND sky130_ef_sc_hd__decap_12
XFILLER_41_213 VGND VGND VPWR VPWR sky130_fd_sc_hd__decap_8
XFILLER_26_265 VPWR VGND VPWR VGND sky130_ef_sc_hd__decap_12
XFILLER_26_221 VPWR VGND VPWR VGND sky130_ef_sc_hd__decap_12
XTAP_TAPCELL_ROW_64_591 VGND VPWR sky130_fd_sc_hd__tapvpwrvgnd_1
XFILLER_53_57 VPWR VGND VPWR VGND sky130_ef_sc_hd__decap_12
XFILLER_41_279 VGND VGND VPWR VPWR sky130_fd_sc_hd__fill_1
XFILLER_5_169 VPWR VGND VPWR VGND sky130_ef_sc_hd__decap_12
XFILLER_5_125 VPWR VGND VPWR VGND sky130_ef_sc_hd__decap_12
XFILLER_64_349 VPWR VGND VPWR VGND sky130_ef_sc_hd__decap_12
XFILLER_64_327 VGND VGND VPWR VPWR sky130_fd_sc_hd__decap_8
XFILLER_32_213 VGND VGND VPWR VPWR sky130_fd_sc_hd__fill_1
X_0961_ net67 net69 net90 net93 VGND VGND VPWR VPWR _0294_ sky130_fd_sc_hd__and4_1
X_0892_ net75 net89 VGND VGND VPWR VPWR _0227_ sky130_fd_sc_hd__nand2_1
X_1375_ _0682_ _0681_ _0683_ VGND VGND VPWR VPWR _0685_ sky130_fd_sc_hd__and3_1
X_1444_ clknet_3_5__leaf_clk _0060_ VGND VGND VPWR VPWR core_out\[11\] sky130_fd_sc_hd__dfxtp_1
XFILLER_55_349 VPWR VGND VPWR VGND sky130_ef_sc_hd__decap_12
XFILLER_63_393 VPWR VGND VPWR VGND sky130_ef_sc_hd__decap_12
XFILLER_23_27 VGND VGND VPWR VPWR sky130_fd_sc_hd__decap_6
XFILLER_2_139 VGND VGND VPWR VPWR sky130_fd_sc_hd__fill_1
XFILLER_58_132 VGND VGND VPWR VPWR sky130_fd_sc_hd__decap_8
XFILLER_46_316 VGND VGND VPWR VPWR sky130_fd_sc_hd__decap_6
XTAP_TAPCELL_ROW_1_150 VGND VPWR sky130_fd_sc_hd__tapvpwrvgnd_1
Xfanout61 _0103_ VGND VGND VPWR VPWR net61 sky130_fd_sc_hd__buf_2
Xfanout94 core_a\[0\] VGND VGND VPWR VPWR net94 sky130_fd_sc_hd__buf_2
XFILLER_6_401 VGND VGND VPWR VPWR sky130_fd_sc_hd__decap_6
Xfanout72 net73 VGND VGND VPWR VPWR net72 sky130_fd_sc_hd__buf_2
Xfanout83 core_a\[6\] VGND VGND VPWR VPWR net83 sky130_fd_sc_hd__clkbuf_4
XFILLER_49_132 VPWR VGND VPWR VGND sky130_ef_sc_hd__decap_12
XFILLER_1_161 VGND VGND VPWR VPWR sky130_fd_sc_hd__decap_6
XFILLER_64_113 VPWR VGND VPWR VGND sky130_ef_sc_hd__decap_12
Xclkbuf_3_7__f_clk clknet_0_clk VGND VGND VPWR VPWR clknet_3_7__leaf_clk sky130_fd_sc_hd__clkbuf_16
X_1091_ _0420_ _0421_ net104 VGND VGND VPWR VPWR _0422_ sky130_fd_sc_hd__o21ai_1
XFILLER_37_305 VPWR VGND VPWR VGND sky130_ef_sc_hd__decap_12
X_1160_ _0487_ _0488_ VGND VGND VPWR VPWR _0489_ sky130_fd_sc_hd__nand2b_1
XFILLER_60_363 VGND VGND VPWR VPWR sky130_fd_sc_hd__fill_1
XFILLER_45_393 VGND VGND VPWR VPWR sky130_fd_sc_hd__decap_8
X_0944_ _0255_ _0275_ _0276_ VGND VGND VPWR VPWR _0278_ sky130_fd_sc_hd__nand3_1
XFILLER_20_216 VGND VGND VPWR VPWR sky130_fd_sc_hd__decap_3
X_0875_ _0208_ _0209_ _0210_ VGND VGND VPWR VPWR _0211_ sky130_fd_sc_hd__and3_1
X_1358_ _0668_ _0669_ VGND VGND VPWR VPWR _0670_ sky130_fd_sc_hd__or2_1
XFILLER_55_113 VPWR VGND VPWR VGND sky130_ef_sc_hd__decap_12
XFILLER_28_338 VGND VGND VPWR VPWR sky130_fd_sc_hd__fill_1
X_1427_ clknet_3_0__leaf_clk _0043_ VGND VGND VPWR VPWR core_b\[2\] sky130_fd_sc_hd__dfxtp_1
X_1289_ core_out\[17\] net123 _0601_ _0610_ VGND VGND VPWR VPWR _0611_ sky130_fd_sc_hd__a2bb2o_4
XFILLER_51_385 VGND VGND VPWR VPWR sky130_fd_sc_hd__decap_6
XFILLER_50_69 VPWR VGND VPWR VGND sky130_ef_sc_hd__decap_12
Xclkload3 clknet_3_3__leaf_clk VGND VGND VPWR VPWR clkload3/Y sky130_fd_sc_hd__inv_6
XTAP_TAPCELL_ROW_21_288 VGND VPWR sky130_fd_sc_hd__tapvpwrvgnd_1
XFILLER_61_105 VGND VGND VPWR VPWR sky130_fd_sc_hd__decap_6
XFILLER_46_124 VGND VGND VPWR VPWR sky130_fd_sc_hd__decap_6
XTAP_TAPCELL_ROW_29_344 VGND VPWR sky130_fd_sc_hd__tapvpwrvgnd_1
XFILLER_19_349 VPWR VGND VPWR VGND sky130_ef_sc_hd__decap_12
XFILLER_61_149 VPWR VGND VPWR VGND sky130_ef_sc_hd__decap_12
XTAP_TAPCELL_ROW_12_222 VGND VPWR sky130_fd_sc_hd__tapvpwrvgnd_1
XFILLER_6_253 VPWR VGND VPWR VGND sky130_ef_sc_hd__decap_12
X_1212_ _0534_ _0538_ VGND VGND VPWR VPWR _0539_ sky130_fd_sc_hd__xnor2_1
X_1143_ _0426_ _0470_ VGND VGND VPWR VPWR _0472_ sky130_fd_sc_hd__xnor2_1
X_1074_ _0401_ _0402_ _0403_ VGND VGND VPWR VPWR _0405_ sky130_fd_sc_hd__o21bai_1
XFILLER_60_193 VGND VGND VPWR VPWR sky130_fd_sc_hd__decap_3
X_0927_ _0256_ _0260_ VGND VGND VPWR VPWR _0261_ sky130_fd_sc_hd__xnor2_1
X_0789_ net156 net105 net59 _0140_ net115 VGND VGND VPWR VPWR _0037_ sky130_fd_sc_hd__o221a_1
X_0858_ _0193_ _0194_ VGND VGND VPWR VPWR _0195_ sky130_fd_sc_hd__xor2_1
XFILLER_29_15 VGND VGND VPWR VPWR sky130_fd_sc_hd__fill_1
Xhold26 net33 VGND VGND VPWR VPWR net142 sky130_fd_sc_hd__dlygate4sd3_1
Xhold59 core_out\[5\] VGND VGND VPWR VPWR net175 sky130_fd_sc_hd__dlygate4sd3_1
XFILLER_43_105 VGND VGND VPWR VPWR sky130_fd_sc_hd__decap_3
Xhold37 net29 VGND VGND VPWR VPWR net153 sky130_fd_sc_hd__dlygate4sd3_1
Xhold48 net22 VGND VGND VPWR VPWR net164 sky130_fd_sc_hd__dlygate4sd3_1
XFILLER_28_179 VGND VGND VPWR VPWR sky130_fd_sc_hd__decap_3
XFILLER_61_57 VPWR VGND VPWR VGND sky130_ef_sc_hd__decap_12
XTAP_TAPCELL_ROW_34_380 VGND VPWR sky130_fd_sc_hd__tapvpwrvgnd_1
XTAP_TAPCELL_ROW_26_325 VGND VPWR sky130_fd_sc_hd__tapvpwrvgnd_1
XFILLER_3_223 VGND VGND VPWR VPWR sky130_fd_sc_hd__fill_1
XFILLER_10_83 VGND VGND VPWR VPWR sky130_fd_sc_hd__fill_1
XFILLER_19_113 VPWR VGND VPWR VGND sky130_ef_sc_hd__decap_12
XFILLER_34_116 VPWR VGND VPWR VGND sky130_ef_sc_hd__decap_12
XFILLER_35_80 VPWR VGND VPWR VGND sky130_ef_sc_hd__decap_12
XFILLER_30_344 VGND VGND VPWR VPWR sky130_fd_sc_hd__fill_1
XFILLER_15_385 VGND VGND VPWR VPWR sky130_fd_sc_hd__decap_6
X_0712_ net108 _0095_ VGND VGND VPWR VPWR _0005_ sky130_fd_sc_hd__and2_1
XFILLER_57_208 VPWR VGND VPWR VGND sky130_ef_sc_hd__decap_12
X_1126_ _0372_ _0412_ _0413_ VGND VGND VPWR VPWR _0456_ sky130_fd_sc_hd__a21bo_1
XFILLER_18_190 VGND VGND VPWR VPWR sky130_fd_sc_hd__decap_6
X_1057_ _0383_ _0386_ VGND VGND VPWR VPWR _0388_ sky130_fd_sc_hd__xor2_1
Xoutput38 net38 VGND VGND VPWR VPWR rdata[26] sky130_fd_sc_hd__buf_2
Xoutput49 net49 VGND VGND VPWR VPWR rdata[7] sky130_fd_sc_hd__buf_2
Xoutput27 net27 VGND VGND VPWR VPWR rdata[16] sky130_fd_sc_hd__buf_2
XFILLER_0_237 VPWR VGND VPWR VGND sky130_ef_sc_hd__decap_12
XFILLER_12_333 VPWR VGND VPWR VGND sky130_ef_sc_hd__decap_12
XFILLER_12_377 VPWR VGND VPWR VGND sky130_ef_sc_hd__decap_12
XTAP_TAPCELL_ROW_45_453 VGND VPWR sky130_fd_sc_hd__tapvpwrvgnd_1
Xclkbuf_0_clk clk VGND VGND VPWR VPWR clknet_0_clk sky130_fd_sc_hd__clkbuf_16
XFILLER_30_174 VPWR VGND VPWR VGND sky130_ef_sc_hd__decap_12
XFILLER_30_163 VGND VGND VPWR VPWR sky130_fd_sc_hd__decap_8
XFILLER_7_51 VGND VGND VPWR VPWR sky130_fd_sc_hd__decap_4
XPHY_EDGE_ROW_15_Right_15 VGND VGND VPWR VPWR sky130_fd_sc_hd__decap_3
XFILLER_26_27 VGND VGND VPWR VPWR sky130_fd_sc_hd__fill_1
X_1109_ _0437_ _0438_ VGND VGND VPWR VPWR _0439_ sky130_fd_sc_hd__nand2_1
XPHY_EDGE_ROW_24_Right_24 VGND VGND VPWR VPWR sky130_fd_sc_hd__decap_3
XFILLER_42_26 VGND VGND VPWR VPWR sky130_fd_sc_hd__fill_2
XFILLER_21_163 VGND VGND VPWR VPWR sky130_fd_sc_hd__decap_4
XPHY_EDGE_ROW_33_Right_33 VGND VGND VPWR VPWR sky130_fd_sc_hd__decap_3
XFILLER_5_329 VGND VGND VPWR VPWR sky130_fd_sc_hd__decap_6
XTAP_TAPCELL_ROW_59_556 VGND VPWR sky130_fd_sc_hd__tapvpwrvgnd_1
XPHY_EDGE_ROW_42_Right_42 VGND VGND VPWR VPWR sky130_fd_sc_hd__decap_3
XTAP_TAPCELL_ROW_42_434 VGND VPWR sky130_fd_sc_hd__tapvpwrvgnd_1
XFILLER_32_406 VGND VGND VPWR VPWR sky130_fd_sc_hd__fill_1
XFILLER_29_285 VGND VGND VPWR VPWR sky130_fd_sc_hd__fill_1
XPHY_EDGE_ROW_51_Right_51 VGND VGND VPWR VPWR sky130_fd_sc_hd__decap_3
XFILLER_12_141 VGND VGND VPWR VPWR sky130_fd_sc_hd__fill_1
X_1460_ clknet_3_6__leaf_clk _0076_ VGND VGND VPWR VPWR core_out\[27\] sky130_fd_sc_hd__dfxtp_1
X_1391_ clknet_3_1__leaf_clk _0007_ VGND VGND VPWR VPWR core_a\[6\] sky130_fd_sc_hd__dfxtp_1
XPHY_EDGE_ROW_60_Right_60 VGND VGND VPWR VPWR sky130_fd_sc_hd__decap_3
XFILLER_35_211 VGND VGND VPWR VPWR sky130_fd_sc_hd__decap_6
XPHY_EDGE_ROW_35_Left_100 VGND VGND VPWR VPWR sky130_fd_sc_hd__decap_3
XFILLER_12_29 VGND VGND VPWR VPWR sky130_fd_sc_hd__decap_4
XTAP_TAPCELL_ROW_64_592 VGND VPWR sky130_fd_sc_hd__tapvpwrvgnd_1
XFILLER_53_69 VPWR VGND VPWR VGND sky130_ef_sc_hd__decap_12
XFILLER_53_36 VGND VGND VPWR VPWR sky130_fd_sc_hd__decap_8
XFILLER_41_247 VPWR VGND VPWR VGND sky130_ef_sc_hd__decap_12
XFILLER_41_225 VPWR VGND VPWR VGND sky130_ef_sc_hd__decap_12
XFILLER_26_277 VPWR VGND VPWR VGND sky130_ef_sc_hd__decap_12
XFILLER_26_233 VGND VGND VPWR VPWR sky130_fd_sc_hd__decap_4
XFILLER_5_137 VPWR VGND VPWR VGND sky130_ef_sc_hd__decap_12
XFILLER_57_391 VGND VGND VPWR VPWR sky130_fd_sc_hd__fill_1
XTAP_TAPCELL_ROW_4_170 VGND VPWR sky130_fd_sc_hd__tapvpwrvgnd_1
X_0960_ net69 net93 _0259_ _0258_ VGND VGND VPWR VPWR _0293_ sky130_fd_sc_hd__a31o_1
X_0891_ _0223_ _0224_ VGND VGND VPWR VPWR _0226_ sky130_fd_sc_hd__xor2_1
X_1374_ _0682_ _0683_ _0681_ VGND VGND VPWR VPWR _0684_ sky130_fd_sc_hd__a21oi_1
X_1443_ clknet_3_5__leaf_clk _0059_ VGND VGND VPWR VPWR core_out\[10\] sky130_fd_sc_hd__dfxtp_1
XFILLER_4_85 VPWR VGND VPWR VGND sky130_ef_sc_hd__decap_12
XFILLER_4_41 VPWR VGND VPWR VGND sky130_ef_sc_hd__decap_12
XFILLER_63_361 VPWR VGND VPWR VGND sky130_ef_sc_hd__decap_12
XFILLER_55_328 VGND VGND VPWR VPWR sky130_fd_sc_hd__decap_8
XFILLER_23_225 VPWR VGND VPWR VGND sky130_ef_sc_hd__decap_12
XFILLER_23_269 VGND VGND VPWR VPWR sky130_fd_sc_hd__decap_8
XFILLER_58_166 VGND VGND VPWR VPWR sky130_fd_sc_hd__decap_6
XFILLER_64_57 VPWR VGND VPWR VGND sky130_ef_sc_hd__decap_12
Xfanout62 _0103_ VGND VGND VPWR VPWR net62 sky130_fd_sc_hd__clkbuf_4
Xfanout73 core_b\[3\] VGND VGND VPWR VPWR net73 sky130_fd_sc_hd__buf_6
Xfanout95 core_a\[0\] VGND VGND VPWR VPWR net95 sky130_fd_sc_hd__clkbuf_2
Xfanout84 net85 VGND VGND VPWR VPWR net84 sky130_fd_sc_hd__buf_4
XFILLER_49_144 VGND VGND VPWR VPWR sky130_fd_sc_hd__fill_1
XFILLER_64_169 VPWR VGND VPWR VGND sky130_ef_sc_hd__decap_12
XFILLER_64_125 VPWR VGND VPWR VGND sky130_ef_sc_hd__decap_12
XFILLER_52_309 VPWR VGND VPWR VGND sky130_ef_sc_hd__decap_12
X_1090_ _0382_ _0418_ _0419_ VGND VGND VPWR VPWR _0421_ sky130_fd_sc_hd__nor3_1
XFILLER_37_317 VPWR VGND VPWR VGND sky130_ef_sc_hd__decap_12
X_0874_ _0184_ _0186_ VGND VGND VPWR VPWR _0210_ sky130_fd_sc_hd__nand2_1
X_0943_ _0255_ _0275_ _0276_ VGND VGND VPWR VPWR _0277_ sky130_fd_sc_hd__and3_1
XTAP_TAPCELL_ROW_15_242 VGND VPWR sky130_fd_sc_hd__tapvpwrvgnd_1
X_1357_ core_out\[28\] net52 VGND VGND VPWR VPWR _0669_ sky130_fd_sc_hd__nor2_1
XFILLER_55_125 VPWR VGND VPWR VGND sky130_ef_sc_hd__decap_12
X_1288_ core_out\[17\] core_out\[16\] net123 VGND VGND VPWR VPWR _0610_ sky130_fd_sc_hd__o21ai_1
XFILLER_28_317 VGND VGND VPWR VPWR sky130_fd_sc_hd__fill_1
XFILLER_28_306 VGND VGND VPWR VPWR sky130_fd_sc_hd__fill_2
X_1426_ clknet_3_1__leaf_clk _0042_ VGND VGND VPWR VPWR core_b\[1\] sky130_fd_sc_hd__dfxtp_1
XFILLER_34_27 VGND VGND VPWR VPWR sky130_fd_sc_hd__fill_1
Xclkload4 clknet_3_4__leaf_clk VGND VGND VPWR VPWR clkload4/Y sky130_fd_sc_hd__bufinv_16
XFILLER_3_405 VGND VGND VPWR VPWR sky130_fd_sc_hd__fill_2
XTAP_TAPCELL_ROW_21_289 VGND VPWR sky130_fd_sc_hd__tapvpwrvgnd_1
XFILLER_59_57 VPWR VGND VPWR VGND sky130_ef_sc_hd__decap_12
XFILLER_46_136 VGND VGND VPWR VPWR sky130_fd_sc_hd__decap_4
XFILLER_34_309 VGND VGND VPWR VPWR sky130_fd_sc_hd__decap_8
XTAP_TAPCELL_ROW_29_345 VGND VPWR sky130_fd_sc_hd__tapvpwrvgnd_1
XTAP_TAPCELL_ROW_12_223 VGND VPWR sky130_fd_sc_hd__tapvpwrvgnd_1
XFILLER_24_71 VGND VGND VPWR VPWR sky130_fd_sc_hd__fill_1
XFILLER_6_265 VPWR VGND VPWR VGND sky130_ef_sc_hd__decap_12
XFILLER_37_136 VGND VGND VPWR VPWR sky130_fd_sc_hd__fill_2
X_1211_ _0536_ _0537_ VGND VGND VPWR VPWR _0538_ sky130_fd_sc_hd__nor2_1
X_1142_ _0426_ _0470_ VGND VGND VPWR VPWR _0471_ sky130_fd_sc_hd__nand2_1
XFILLER_52_139 VGND VGND VPWR VPWR sky130_fd_sc_hd__fill_1
XFILLER_45_191 VPWR VGND VPWR VGND sky130_ef_sc_hd__decap_12
X_1073_ _0401_ _0402_ _0403_ VGND VGND VPWR VPWR _0404_ sky130_fd_sc_hd__or3b_4
X_0857_ _0174_ _0175_ _0172_ VGND VGND VPWR VPWR _0194_ sky130_fd_sc_hd__o21ai_1
X_0926_ _0258_ _0259_ VGND VGND VPWR VPWR _0260_ sky130_fd_sc_hd__and2b_1
XFILLER_20_29 VGND VGND VPWR VPWR sky130_fd_sc_hd__fill_1
X_0788_ core_out\[28\] net60 VGND VGND VPWR VPWR _0140_ sky130_fd_sc_hd__and2_1
Xhold27 net30 VGND VGND VPWR VPWR net143 sky130_fd_sc_hd__dlygate4sd3_1
X_1409_ clknet_3_5__leaf_clk _0025_ VGND VGND VPWR VPWR net27 sky130_fd_sc_hd__dfxtp_1
Xhold38 net26 VGND VGND VPWR VPWR net154 sky130_fd_sc_hd__dlygate4sd3_1
XFILLER_56_401 VGND VGND VPWR VPWR sky130_fd_sc_hd__decap_6
XFILLER_45_26 VGND VGND VPWR VPWR sky130_fd_sc_hd__fill_2
Xhold49 net51 VGND VGND VPWR VPWR net165 sky130_fd_sc_hd__dlygate4sd3_1
XFILLER_16_309 VPWR VGND VPWR VGND sky130_ef_sc_hd__decap_12
XFILLER_61_69 VPWR VGND VPWR VGND sky130_ef_sc_hd__decap_12
XTAP_TAPCELL_ROW_34_381 VGND VPWR sky130_fd_sc_hd__tapvpwrvgnd_1
XFILLER_59_272 VGND VGND VPWR VPWR sky130_fd_sc_hd__decap_8
XFILLER_59_250 VGND VGND VPWR VPWR sky130_fd_sc_hd__decap_8
XFILLER_3_279 VGND VGND VPWR VPWR sky130_fd_sc_hd__fill_1
XFILLER_19_125 VPWR VGND VPWR VGND sky130_ef_sc_hd__decap_12
XFILLER_35_92 VGND VGND VPWR VPWR sky130_fd_sc_hd__fill_2
XFILLER_34_128 VPWR VGND VPWR VGND sky130_ef_sc_hd__decap_12
XFILLER_19_169 VGND VGND VPWR VPWR sky130_fd_sc_hd__fill_1
XFILLER_42_183 VPWR VGND VPWR VGND sky130_ef_sc_hd__decap_12
XFILLER_30_378 VGND VGND VPWR VPWR sky130_fd_sc_hd__decap_8
X_0711_ net86 net15 _0090_ VGND VGND VPWR VPWR _0095_ sky130_fd_sc_hd__mux2_1
XFILLER_32_3 VGND VGND VPWR VPWR sky130_fd_sc_hd__decap_8
XTAP_TAPCELL_ROW_48_473 VGND VPWR sky130_fd_sc_hd__tapvpwrvgnd_1
X_1125_ _0372_ _0413_ _0412_ _0373_ VGND VGND VPWR VPWR _0455_ sky130_fd_sc_hd__and4b_1
XFILLER_15_18 VGND VGND VPWR VPWR sky130_fd_sc_hd__decap_6
X_1056_ _0383_ _0386_ VGND VGND VPWR VPWR _0387_ sky130_fd_sc_hd__and2_1
Xoutput39 net39 VGND VGND VPWR VPWR rdata[27] sky130_fd_sc_hd__buf_2
Xoutput28 net28 VGND VGND VPWR VPWR rdata[17] sky130_fd_sc_hd__buf_2
X_0909_ _0211_ _0213_ _0242_ VGND VGND VPWR VPWR _0244_ sky130_fd_sc_hd__nand3b_1
XFILLER_0_249 VGND VGND VPWR VPWR sky130_fd_sc_hd__decap_3
XFILLER_56_253 VPWR VGND VPWR VGND sky130_ef_sc_hd__decap_12
XFILLER_16_128 VPWR VGND VPWR VGND sky130_ef_sc_hd__decap_12
XFILLER_24_161 VPWR VGND VPWR VGND sky130_ef_sc_hd__decap_12
XFILLER_12_345 VPWR VGND VPWR VGND sky130_ef_sc_hd__decap_12
XFILLER_12_389 VPWR VGND VPWR VGND sky130_ef_sc_hd__decap_12
XFILLER_62_234 VGND VGND VPWR VPWR sky130_fd_sc_hd__fill_2
XTAP_TAPCELL_ROW_45_454 VGND VPWR sky130_fd_sc_hd__tapvpwrvgnd_1
XFILLER_30_197 VPWR VGND VPWR VGND sky130_ef_sc_hd__decap_12
XFILLER_30_186 VGND VGND VPWR VPWR sky130_fd_sc_hd__decap_8
XFILLER_7_393 VPWR VGND VPWR VGND sky130_ef_sc_hd__decap_12
XFILLER_53_223 VGND VGND VPWR VPWR sky130_fd_sc_hd__fill_1
XFILLER_38_253 VGND VGND VPWR VPWR sky130_fd_sc_hd__decap_8
XFILLER_38_231 VPWR VGND VPWR VGND sky130_ef_sc_hd__decap_12
X_1039_ _0367_ _0369_ _0300_ VGND VGND VPWR VPWR _0371_ sky130_fd_sc_hd__o21ai_1
X_1108_ net68 net84 _0433_ _0436_ VGND VGND VPWR VPWR _0438_ sky130_fd_sc_hd__a22o_1
XFILLER_21_197 VGND VGND VPWR VPWR sky130_fd_sc_hd__fill_1
XTAP_TAPCELL_ROW_42_435 VGND VPWR sky130_fd_sc_hd__tapvpwrvgnd_1
XFILLER_16_94 VGND VGND VPWR VPWR sky130_fd_sc_hd__decap_8
XTAP_TAPCELL_ROW_50_490 VGND VPWR sky130_fd_sc_hd__tapvpwrvgnd_1
XFILLER_32_82 VGND VGND VPWR VPWR sky130_fd_sc_hd__fill_2
XFILLER_8_113 VPWR VGND VPWR VGND sky130_ef_sc_hd__decap_12
XFILLER_12_197 VGND VGND VPWR VPWR sky130_fd_sc_hd__decap_8
XFILLER_4_363 VGND VGND VPWR VPWR sky130_fd_sc_hd__fill_1
XTAP_TAPCELL_ROW_7_190 VGND VPWR sky130_fd_sc_hd__tapvpwrvgnd_1
X_1390_ clknet_3_1__leaf_clk _0006_ VGND VGND VPWR VPWR core_a\[5\] sky130_fd_sc_hd__dfxtp_1
XFILLER_58_304 VGND VGND VPWR VPWR sky130_fd_sc_hd__decap_4
XTAP_TAPCELL_ROW_64_593 VGND VPWR sky130_fd_sc_hd__tapvpwrvgnd_1
XFILLER_41_259 VPWR VGND VPWR VGND sky130_ef_sc_hd__decap_12
XFILLER_41_237 VGND VGND VPWR VPWR sky130_fd_sc_hd__decap_4
XFILLER_26_289 VPWR VGND VPWR VGND sky130_ef_sc_hd__decap_12
XFILLER_26_245 VGND VGND VPWR VPWR sky130_fd_sc_hd__decap_6
XFILLER_5_149 VPWR VGND VPWR VGND sky130_ef_sc_hd__decap_12
XFILLER_5_105 VGND VGND VPWR VPWR sky130_fd_sc_hd__decap_6
XFILLER_49_337 VGND VGND VPWR VPWR sky130_fd_sc_hd__decap_3
XFILLER_49_304 VGND VGND VPWR VPWR sky130_fd_sc_hd__fill_2
XFILLER_64_307 VGND VGND VPWR VPWR sky130_fd_sc_hd__fill_1
XTAP_TAPCELL_ROW_4_171 VGND VPWR sky130_fd_sc_hd__tapvpwrvgnd_1
XFILLER_17_201 VGND VGND VPWR VPWR sky130_fd_sc_hd__fill_2
XFILLER_17_212 VPWR VGND VPWR VGND sky130_ef_sc_hd__decap_12
X_0890_ _0223_ _0224_ VGND VGND VPWR VPWR _0225_ sky130_fd_sc_hd__nor2_1
X_1442_ clknet_3_5__leaf_clk _0058_ VGND VGND VPWR VPWR core_out\[9\] sky130_fd_sc_hd__dfxtp_1
X_1373_ core_out\[29\] core_out\[28\] net52 VGND VGND VPWR VPWR _0683_ sky130_fd_sc_hd__o21ai_1
XFILLER_4_97 VPWR VGND VPWR VGND sky130_ef_sc_hd__decap_12
XFILLER_4_53 VPWR VGND VPWR VGND sky130_ef_sc_hd__decap_12
XFILLER_63_373 VPWR VGND VPWR VGND sky130_ef_sc_hd__decap_12
XTAP_TAPCELL_ROW_53_508 VGND VPWR sky130_fd_sc_hd__tapvpwrvgnd_1
XFILLER_48_381 VGND VGND VPWR VPWR sky130_fd_sc_hd__fill_1
XFILLER_23_237 VGND VGND VPWR VPWR sky130_fd_sc_hd__decap_4
XFILLER_31_281 VGND VGND VPWR VPWR sky130_fd_sc_hd__decap_8
XFILLER_48_37 VGND VGND VPWR VPWR sky130_fd_sc_hd__fill_1
XFILLER_48_26 VGND VGND VPWR VPWR sky130_fd_sc_hd__fill_2
XPHY_EDGE_ROW_18_Left_83 VGND VGND VPWR VPWR sky130_fd_sc_hd__decap_3
XFILLER_64_69 VPWR VGND VPWR VGND sky130_ef_sc_hd__decap_12
XFILLER_46_329 VGND VGND VPWR VPWR sky130_fd_sc_hd__decap_4
XPHY_EDGE_ROW_54_Left_119 VGND VGND VPWR VPWR sky130_fd_sc_hd__decap_3
Xfanout96 net97 VGND VGND VPWR VPWR net96 sky130_fd_sc_hd__buf_2
Xfanout52 _0591_ VGND VGND VPWR VPWR net52 sky130_fd_sc_hd__buf_2
XFILLER_13_51 VGND VGND VPWR VPWR sky130_fd_sc_hd__decap_4
Xfanout85 core_a\[5\] VGND VGND VPWR VPWR net85 sky130_fd_sc_hd__buf_2
Xfanout74 net75 VGND VGND VPWR VPWR net74 sky130_fd_sc_hd__buf_6
XFILLER_22_292 VPWR VGND VPWR VGND sky130_ef_sc_hd__decap_12
XPHY_EDGE_ROW_63_Left_128 VGND VGND VPWR VPWR sky130_fd_sc_hd__decap_3
XFILLER_37_329 VGND VGND VPWR VPWR sky130_fd_sc_hd__decap_6
XFILLER_64_137 VGND VGND VPWR VPWR sky130_fd_sc_hd__decap_3
XFILLER_60_365 VPWR VGND VPWR VGND sky130_ef_sc_hd__decap_12
XFILLER_60_321 VPWR VGND VPWR VGND sky130_ef_sc_hd__decap_12
XFILLER_45_362 VGND VGND VPWR VPWR sky130_fd_sc_hd__decap_3
XTAP_TAPCELL_ROW_15_243 VGND VPWR sky130_fd_sc_hd__tapvpwrvgnd_1
XFILLER_62_3 VPWR VGND VPWR VGND sky130_ef_sc_hd__decap_12
X_0873_ _0206_ _0207_ _0199_ VGND VGND VPWR VPWR _0209_ sky130_fd_sc_hd__a21o_1
X_0942_ _0272_ _0273_ _0274_ VGND VGND VPWR VPWR _0276_ sky130_fd_sc_hd__a21o_1
XFILLER_13_281 VPWR VGND VPWR VGND sky130_ef_sc_hd__decap_12
X_1425_ clknet_3_1__leaf_clk _0041_ VGND VGND VPWR VPWR core_b\[0\] sky130_fd_sc_hd__dfxtp_4
X_1356_ core_out\[28\] net52 VGND VGND VPWR VPWR _0668_ sky130_fd_sc_hd__and2_1
XFILLER_55_137 VGND VGND VPWR VPWR sky130_fd_sc_hd__fill_1
X_1287_ core_out\[18\] net55 VGND VGND VPWR VPWR _0609_ sky130_fd_sc_hd__xnor2_2
Xclkload5 clknet_3_7__leaf_clk VGND VGND VPWR VPWR clkload5/Y sky130_fd_sc_hd__clkinvlp_4
XFILLER_36_373 VPWR VGND VPWR VGND sky130_ef_sc_hd__decap_12
XFILLER_50_49 VGND VGND VPWR VPWR sky130_fd_sc_hd__decap_6
XFILLER_59_69 VPWR VGND VPWR VGND sky130_ef_sc_hd__decap_12
XPHY_EDGE_ROW_3_Left_68 VGND VGND VPWR VPWR sky130_fd_sc_hd__decap_3
XTAP_TAPCELL_ROW_29_346 VGND VPWR sky130_fd_sc_hd__tapvpwrvgnd_1
XFILLER_10_251 VGND VGND VPWR VPWR sky130_fd_sc_hd__fill_1
XTAP_TAPCELL_ROW_12_224 VGND VPWR sky130_fd_sc_hd__tapvpwrvgnd_1
XFILLER_24_83 VGND VGND VPWR VPWR sky130_fd_sc_hd__fill_1
XFILLER_6_277 VPWR VGND VPWR VGND sky130_ef_sc_hd__decap_12
XFILLER_37_159 VGND VGND VPWR VPWR sky130_fd_sc_hd__decap_3
X_1210_ net82 net80 net66 net65 VGND VGND VPWR VPWR _0537_ sky130_fd_sc_hd__and4b_1
X_1141_ _0466_ _0469_ VGND VGND VPWR VPWR _0470_ sky130_fd_sc_hd__xor2_1
X_1072_ _0350_ net56 _0357_ VGND VGND VPWR VPWR _0403_ sky130_fd_sc_hd__a21bo_1
X_0787_ net161 net105 net59 _0139_ net115 VGND VGND VPWR VPWR _0036_ sky130_fd_sc_hd__o221a_1
X_0856_ _0191_ _0192_ VGND VGND VPWR VPWR _0193_ sky130_fd_sc_hd__nand2_1
X_0925_ core_b\[3\] net89 net90 net71 VGND VGND VPWR VPWR _0259_ sky130_fd_sc_hd__a22o_1
Xhold28 net34 VGND VGND VPWR VPWR net144 sky130_fd_sc_hd__dlygate4sd3_1
X_1408_ clknet_3_5__leaf_clk _0024_ VGND VGND VPWR VPWR net26 sky130_fd_sc_hd__dfxtp_1
Xhold39 net21 VGND VGND VPWR VPWR net155 sky130_fd_sc_hd__dlygate4sd3_1
X_1339_ core_out\[26\] net120 VGND VGND VPWR VPWR _0653_ sky130_fd_sc_hd__or2_1
XFILLER_28_126 VPWR VGND VPWR VGND sky130_ef_sc_hd__decap_12
XFILLER_61_15 VPWR VGND VPWR VGND sky130_ef_sc_hd__decap_12
XFILLER_24_365 VPWR VGND VPWR VGND sky130_ef_sc_hd__decap_12
XFILLER_3_225 VPWR VGND VPWR VGND sky130_ef_sc_hd__decap_12
XFILLER_10_85 VPWR VGND VPWR VGND sky130_ef_sc_hd__decap_12
XFILLER_19_83 VPWR VGND VPWR VGND sky130_ef_sc_hd__decap_12
XFILLER_19_137 VPWR VGND VPWR VGND sky130_ef_sc_hd__decap_12
XFILLER_19_159 VGND VGND VPWR VPWR sky130_fd_sc_hd__decap_8
XFILLER_42_195 VGND VGND VPWR VPWR sky130_fd_sc_hd__fill_1
XFILLER_42_173 VGND VGND VPWR VPWR sky130_fd_sc_hd__fill_2
X_0710_ net108 _0094_ VGND VGND VPWR VPWR _0004_ sky130_fd_sc_hd__and2_1
XTAP_TAPCELL_ROW_48_474 VGND VPWR sky130_fd_sc_hd__tapvpwrvgnd_1
X_1124_ _0451_ _0453_ VGND VGND VPWR VPWR _0454_ sky130_fd_sc_hd__nand2_1
X_1055_ _0384_ _0385_ VGND VGND VPWR VPWR _0386_ sky130_fd_sc_hd__nor2_1
XFILLER_21_335 VGND VGND VPWR VPWR sky130_fd_sc_hd__fill_1
X_0908_ _0211_ _0240_ _0241_ VGND VGND VPWR VPWR _0243_ sky130_fd_sc_hd__nand3_1
Xoutput29 net29 VGND VGND VPWR VPWR rdata[18] sky130_fd_sc_hd__buf_2
X_0839_ net97 _0176_ VGND VGND VPWR VPWR _0177_ sky130_fd_sc_hd__nand2_1
XFILLER_56_265 VPWR VGND VPWR VGND sky130_ef_sc_hd__decap_12
XFILLER_56_243 VGND VGND VPWR VPWR sky130_fd_sc_hd__fill_1
XFILLER_56_26 VGND VGND VPWR VPWR sky130_fd_sc_hd__fill_2
XFILLER_24_173 VPWR VGND VPWR VGND sky130_ef_sc_hd__decap_12
XFILLER_24_195 VGND VGND VPWR VPWR sky130_fd_sc_hd__fill_1
XFILLER_12_357 VGND VGND VPWR VPWR sky130_fd_sc_hd__decap_6
XFILLER_62_213 VGND VGND VPWR VPWR sky130_fd_sc_hd__decap_4
XFILLER_47_221 VGND VGND VPWR VPWR sky130_fd_sc_hd__decap_3
XPHY_EDGE_ROW_6_Left_71 VGND VGND VPWR VPWR sky130_fd_sc_hd__decap_3
XFILLER_62_268 VGND VGND VPWR VPWR sky130_fd_sc_hd__fill_1
XTAP_TAPCELL_ROW_45_455 VGND VPWR sky130_fd_sc_hd__tapvpwrvgnd_1
XFILLER_15_184 VPWR VGND VPWR VGND sky130_ef_sc_hd__decap_12
XFILLER_7_86 VGND VGND VPWR VPWR sky130_fd_sc_hd__decap_8
XFILLER_7_361 VPWR VGND VPWR VGND sky130_ef_sc_hd__decap_12
XFILLER_38_243 VGND VGND VPWR VPWR sky130_fd_sc_hd__decap_8
XFILLER_53_246 VGND VGND VPWR VPWR sky130_fd_sc_hd__fill_1
X_1038_ _0369_ _0367_ _0300_ VGND VGND VPWR VPWR _0370_ sky130_fd_sc_hd__or3_4
XPHY_EDGE_ROW_5_Right_5 VGND VGND VPWR VPWR sky130_fd_sc_hd__decap_3
X_1107_ net68 net84 _0433_ _0436_ VGND VGND VPWR VPWR _0437_ sky130_fd_sc_hd__nand4_1
XFILLER_17_405 VGND VGND VPWR VPWR sky130_fd_sc_hd__fill_2
XTAP_TAPCELL_ROW_42_436 VGND VPWR sky130_fd_sc_hd__tapvpwrvgnd_1
XPHY_EDGE_ROW_32_Left_97 VGND VGND VPWR VPWR sky130_fd_sc_hd__decap_3
XFILLER_8_125 VGND VGND VPWR VPWR sky130_fd_sc_hd__decap_6
XTAP_TAPCELL_ROW_50_491 VGND VPWR sky130_fd_sc_hd__tapvpwrvgnd_1
XFILLER_8_158 VPWR VGND VPWR VGND sky130_ef_sc_hd__decap_12
XTAP_TAPCELL_ROW_7_191 VGND VPWR sky130_fd_sc_hd__tapvpwrvgnd_1
XFILLER_35_279 VGND VGND VPWR VPWR sky130_fd_sc_hd__fill_1
XTAP_TAPCELL_ROW_64_594 VGND VPWR sky130_fd_sc_hd__tapvpwrvgnd_1
XFILLER_57_393 VPWR VGND VPWR VGND sky130_ef_sc_hd__decap_12
XFILLER_32_205 VGND VGND VPWR VPWR sky130_fd_sc_hd__fill_1
XFILLER_17_279 VGND VGND VPWR VPWR sky130_fd_sc_hd__fill_1
XFILLER_57_6 VPWR VGND VPWR VGND sky130_ef_sc_hd__decap_12
X_1441_ clknet_3_6__leaf_clk _0057_ VGND VGND VPWR VPWR core_out\[8\] sky130_fd_sc_hd__dfxtp_1
XFILLER_4_65 VPWR VGND VPWR VGND sky130_ef_sc_hd__decap_12
X_1372_ _0666_ _0665_ _0671_ _0674_ VGND VGND VPWR VPWR _0682_ sky130_fd_sc_hd__o211ai_2
XFILLER_48_371 VGND VGND VPWR VPWR sky130_fd_sc_hd__fill_1
XFILLER_48_360 VGND VGND VPWR VPWR sky130_fd_sc_hd__decap_4
XFILLER_63_385 VGND VGND VPWR VPWR sky130_fd_sc_hd__decap_6
XTAP_TAPCELL_ROW_61_564 VGND VPWR sky130_fd_sc_hd__tapvpwrvgnd_1
XTAP_TAPCELL_ROW_53_509 VGND VPWR sky130_fd_sc_hd__tapvpwrvgnd_1
XTAP_TAPCELL_ROW_18_263 VGND VPWR sky130_fd_sc_hd__tapvpwrvgnd_1
XFILLER_2_109 VPWR VGND VPWR VGND sky130_ef_sc_hd__decap_12
XFILLER_48_49 VPWR VGND VPWR VGND sky130_ef_sc_hd__decap_12
XFILLER_64_15 VPWR VGND VPWR VGND sky130_ef_sc_hd__decap_12
XFILLER_54_363 VGND VGND VPWR VPWR sky130_fd_sc_hd__fill_1
XFILLER_39_393 VPWR VGND VPWR VGND sky130_ef_sc_hd__decap_12
Xfanout97 net104 VGND VGND VPWR VPWR net97 sky130_fd_sc_hd__buf_2
Xfanout53 _0591_ VGND VGND VPWR VPWR net53 sky130_fd_sc_hd__buf_4
Xfanout86 net87 VGND VGND VPWR VPWR net86 sky130_fd_sc_hd__buf_4
Xfanout75 core_b\[2\] VGND VGND VPWR VPWR net75 sky130_fd_sc_hd__buf_4
XFILLER_13_96 VGND VGND VPWR VPWR sky130_fd_sc_hd__fill_1
XFILLER_64_105 VGND VGND VPWR VPWR sky130_fd_sc_hd__decap_3
XFILLER_60_377 VPWR VGND VPWR VGND sky130_ef_sc_hd__decap_12
XFILLER_60_333 VPWR VGND VPWR VGND sky130_ef_sc_hd__decap_12
XFILLER_45_374 VPWR VGND VPWR VGND sky130_ef_sc_hd__decap_12
X_0941_ _0272_ _0273_ _0274_ VGND VGND VPWR VPWR _0275_ sky130_fd_sc_hd__nand3_2
XTAP_TAPCELL_ROW_15_244 VGND VPWR sky130_fd_sc_hd__tapvpwrvgnd_1
X_0872_ _0199_ _0206_ _0207_ VGND VGND VPWR VPWR _0208_ sky130_fd_sc_hd__nand3_1
XFILLER_13_293 VPWR VGND VPWR VGND sky130_ef_sc_hd__decap_12
X_1424_ clknet_3_3__leaf_clk _0040_ VGND VGND VPWR VPWR net44 sky130_fd_sc_hd__dfxtp_1
X_1355_ _0665_ _0666_ VGND VGND VPWR VPWR _0667_ sky130_fd_sc_hd__nor2_1
XFILLER_55_105 VGND VGND VPWR VPWR sky130_fd_sc_hd__decap_6
X_1286_ core_out\[18\] net123 VGND VGND VPWR VPWR _0608_ sky130_fd_sc_hd__nand2_1
XFILLER_36_385 VPWR VGND VPWR VGND sky130_ef_sc_hd__decap_12
XFILLER_36_363 VGND VGND VPWR VPWR sky130_fd_sc_hd__fill_1
XFILLER_59_15 VPWR VGND VPWR VGND sky130_ef_sc_hd__decap_12
XFILLER_46_149 VPWR VGND VPWR VGND sky130_ef_sc_hd__decap_12
XFILLER_40_50 VPWR VGND VPWR VGND sky130_ef_sc_hd__decap_12
XFILLER_6_245 VGND VGND VPWR VPWR sky130_fd_sc_hd__decap_6
XTAP_TAPCELL_ROW_12_225 VGND VPWR sky130_fd_sc_hd__tapvpwrvgnd_1
XTAP_TAPCELL_ROW_20_280 VGND VPWR sky130_fd_sc_hd__tapvpwrvgnd_1
XFILLER_24_95 VPWR VGND VPWR VGND sky130_ef_sc_hd__decap_12
XFILLER_27_7 VGND VGND VPWR VPWR sky130_fd_sc_hd__decap_6
XFILLER_6_289 VPWR VGND VPWR VGND sky130_ef_sc_hd__decap_12
XFILLER_37_116 VPWR VGND VPWR VGND sky130_ef_sc_hd__decap_12
XFILLER_1_55 VGND VGND VPWR VPWR sky130_fd_sc_hd__fill_1
X_1140_ _0467_ _0468_ VGND VGND VPWR VPWR _0469_ sky130_fd_sc_hd__nor2_1
XFILLER_18_363 VGND VGND VPWR VPWR sky130_fd_sc_hd__fill_1
X_1071_ _0399_ net118 _0394_ VGND VGND VPWR VPWR _0402_ sky130_fd_sc_hd__a21oi_1
XFILLER_60_185 VGND VGND VPWR VPWR sky130_fd_sc_hd__decap_8
XFILLER_60_141 VPWR VGND VPWR VGND sky130_ef_sc_hd__decap_12
X_0924_ net71 net73 net89 net90 VGND VGND VPWR VPWR _0258_ sky130_fd_sc_hd__and4_1
X_0786_ core_out\[27\] net60 VGND VGND VPWR VPWR _0139_ sky130_fd_sc_hd__and2_1
X_0855_ core_out\[3\] _0190_ VGND VGND VPWR VPWR _0192_ sky130_fd_sc_hd__or2_1
X_1338_ _0651_ net100 _0652_ net9 VGND VGND VPWR VPWR _0074_ sky130_fd_sc_hd__a211oi_1
Xhold29 net27 VGND VGND VPWR VPWR net145 sky130_fd_sc_hd__dlygate4sd3_1
X_1407_ clknet_3_5__leaf_clk _0023_ VGND VGND VPWR VPWR net25 sky130_fd_sc_hd__dfxtp_1
XFILLER_28_138 VGND VGND VPWR VPWR sky130_fd_sc_hd__fill_2
X_1269_ _0592_ _0593_ VGND VGND VPWR VPWR _0594_ sky130_fd_sc_hd__or2_1
XFILLER_24_377 VPWR VGND VPWR VGND sky130_ef_sc_hd__decap_12
XFILLER_61_27 VPWR VGND VPWR VGND sky130_ef_sc_hd__decap_12
XFILLER_3_237 VPWR VGND VPWR VGND sky130_ef_sc_hd__decap_12
XFILLER_10_97 VPWR VGND VPWR VGND sky130_ef_sc_hd__decap_12
XFILLER_59_263 VGND VGND VPWR VPWR sky130_fd_sc_hd__decap_6
XFILLER_42_141 VPWR VGND VPWR VGND sky130_ef_sc_hd__decap_12
XFILLER_30_369 VGND VGND VPWR VPWR sky130_fd_sc_hd__fill_1
XFILLER_18_3 VPWR VGND VPWR VGND sky130_ef_sc_hd__decap_12
XTAP_TAPCELL_ROW_48_475 VGND VPWR sky130_fd_sc_hd__tapvpwrvgnd_1
X_1123_ _0408_ _0410_ _0450_ VGND VGND VPWR VPWR _0453_ sky130_fd_sc_hd__o21ai_1
X_1054_ net90 net88 net67 core_b\[7\] VGND VGND VPWR VPWR _0385_ sky130_fd_sc_hd__and4b_1
X_0907_ _0240_ _0241_ VGND VGND VPWR VPWR _0242_ sky130_fd_sc_hd__nand2_1
XFILLER_33_196 VPWR VGND VPWR VGND sky130_ef_sc_hd__decap_12
XFILLER_33_185 VGND VGND VPWR VPWR sky130_fd_sc_hd__fill_1
X_0769_ net153 net106 net57 _0130_ net113 VGND VGND VPWR VPWR _0027_ sky130_fd_sc_hd__o221a_1
X_0838_ _0174_ _0175_ VGND VGND VPWR VPWR _0176_ sky130_fd_sc_hd__xnor2_1
XFILLER_56_277 VPWR VGND VPWR VGND sky130_ef_sc_hd__decap_12
XFILLER_8_307 VGND VGND VPWR VPWR sky130_fd_sc_hd__fill_1
XTAP_TAPCELL_ROW_45_456 VGND VPWR sky130_fd_sc_hd__tapvpwrvgnd_1
XFILLER_35_406 VGND VGND VPWR VPWR sky130_fd_sc_hd__fill_1
XFILLER_30_155 VGND VGND VPWR VPWR sky130_fd_sc_hd__fill_1
XFILLER_11_391 VGND VGND VPWR VPWR sky130_fd_sc_hd__fill_1
XFILLER_15_196 VGND VGND VPWR VPWR sky130_fd_sc_hd__decap_8
XFILLER_7_373 VPWR VGND VPWR VGND sky130_ef_sc_hd__decap_12
XFILLER_38_211 VGND VGND VPWR VPWR sky130_fd_sc_hd__decap_3
XFILLER_26_19 VGND VGND VPWR VPWR sky130_fd_sc_hd__decap_8
X_1106_ net70 net72 net80 net82 VGND VGND VPWR VPWR _0436_ sky130_fd_sc_hd__nand4_1
XFILLER_42_29 VPWR VGND VPWR VGND sky130_ef_sc_hd__decap_12
XFILLER_42_18 VGND VGND VPWR VPWR sky130_fd_sc_hd__decap_8
X_1037_ _0366_ _0364_ _0315_ _0318_ VGND VGND VPWR VPWR _0369_ sky130_fd_sc_hd__o211a_1
XFILLER_21_111 VGND VGND VPWR VPWR sky130_fd_sc_hd__fill_1
XFILLER_29_255 VGND VGND VPWR VPWR sky130_fd_sc_hd__decap_6
XFILLER_16_41 VPWR VGND VPWR VGND sky130_ef_sc_hd__decap_12
XTAP_TAPCELL_ROW_50_492 VGND VPWR sky130_fd_sc_hd__tapvpwrvgnd_1
XTAP_TAPCELL_ROW_42_437 VGND VPWR sky130_fd_sc_hd__tapvpwrvgnd_1
XFILLER_32_62 VPWR VGND VPWR VGND sky130_ef_sc_hd__decap_12
XPHY_EDGE_ROW_11_Right_11 VGND VGND VPWR VPWR sky130_fd_sc_hd__decap_3
XFILLER_12_111 VGND VGND VPWR VPWR sky130_fd_sc_hd__fill_1
XFILLER_12_133 VGND VGND VPWR VPWR sky130_fd_sc_hd__fill_2
XFILLER_12_177 VGND VGND VPWR VPWR sky130_fd_sc_hd__fill_1
XFILLER_4_365 VPWR VGND VPWR VGND sky130_ef_sc_hd__decap_12
XFILLER_4_321 VPWR VGND VPWR VGND sky130_ef_sc_hd__decap_12
XPHY_EDGE_ROW_20_Right_20 VGND VGND VPWR VPWR sky130_fd_sc_hd__decap_3
XFILLER_57_81 VPWR VGND VPWR VGND sky130_ef_sc_hd__decap_12
XTAP_TAPCELL_ROW_7_192 VGND VPWR sky130_fd_sc_hd__tapvpwrvgnd_1
XFILLER_35_225 VPWR VGND VPWR VGND sky130_ef_sc_hd__decap_12
XTAP_TAPCELL_ROW_56_529 VGND VPWR sky130_fd_sc_hd__tapvpwrvgnd_1
XFILLER_37_18 VGND VGND VPWR VPWR sky130_fd_sc_hd__fill_1
XTAP_TAPCELL_ROW_64_595 VGND VPWR sky130_fd_sc_hd__tapvpwrvgnd_1
XFILLER_64_309 VGND VGND VPWR VPWR sky130_fd_sc_hd__fill_2
XFILLER_57_361 VPWR VGND VPWR VGND sky130_ef_sc_hd__decap_12
XFILLER_1_335 VGND VGND VPWR VPWR sky130_fd_sc_hd__fill_1
XFILLER_17_225 VGND VGND VPWR VPWR sky130_fd_sc_hd__decap_6
XFILLER_40_250 VGND VGND VPWR VPWR sky130_fd_sc_hd__fill_2
X_1371_ _0680_ VGND VGND VPWR VPWR _0681_ sky130_fd_sc_hd__inv_2
X_1440_ clknet_3_6__leaf_clk _0056_ VGND VGND VPWR VPWR core_out\[7\] sky130_fd_sc_hd__dfxtp_1
XFILLER_4_195 VGND VGND VPWR VPWR sky130_fd_sc_hd__fill_1
XFILLER_4_77 VGND VGND VPWR VPWR sky130_fd_sc_hd__decap_6
XTAP_TAPCELL_ROW_61_565 VGND VPWR sky130_fd_sc_hd__tapvpwrvgnd_1
Xclkbuf_3_2__f_clk clknet_0_clk VGND VGND VPWR VPWR clknet_3_2__leaf_clk sky130_fd_sc_hd__clkbuf_16
XFILLER_31_250 VPWR VGND VPWR VGND sky130_ef_sc_hd__decap_12
XTAP_TAPCELL_ROW_18_264 VGND VPWR sky130_fd_sc_hd__tapvpwrvgnd_1
XFILLER_64_27 VGND VGND VPWR VPWR sky130_fd_sc_hd__fill_1
Xfanout54 _0591_ VGND VGND VPWR VPWR net54 sky130_fd_sc_hd__clkbuf_2
Xfanout76 net77 VGND VGND VPWR VPWR net76 sky130_fd_sc_hd__buf_2
Xfanout98 net104 VGND VGND VPWR VPWR net98 sky130_fd_sc_hd__buf_2
Xfanout65 core_b\[7\] VGND VGND VPWR VPWR net65 sky130_fd_sc_hd__buf_6
XFILLER_10_401 VGND VGND VPWR VPWR sky130_fd_sc_hd__decap_6
Xfanout87 core_a\[4\] VGND VGND VPWR VPWR net87 sky130_fd_sc_hd__buf_2
XFILLER_49_169 VPWR VGND VPWR VGND sky130_ef_sc_hd__decap_12
XFILLER_38_83 VGND VGND VPWR VPWR sky130_fd_sc_hd__fill_1
XFILLER_38_50 VGND VGND VPWR VPWR sky130_fd_sc_hd__fill_2
XFILLER_60_389 VPWR VGND VPWR VGND sky130_ef_sc_hd__decap_12
XFILLER_60_345 VPWR VGND VPWR VGND sky130_ef_sc_hd__decap_12
XFILLER_45_386 VGND VGND VPWR VPWR sky130_fd_sc_hd__decap_6
X_0940_ _0226_ _0234_ _0233_ VGND VGND VPWR VPWR _0274_ sky130_fd_sc_hd__a21bo_1
XFILLER_9_232 VGND VGND VPWR VPWR sky130_fd_sc_hd__decap_6
XTAP_TAPCELL_ROW_15_245 VGND VPWR sky130_fd_sc_hd__tapvpwrvgnd_1
X_0871_ _0203_ _0204_ _0205_ VGND VGND VPWR VPWR _0207_ sky130_fd_sc_hd__a21o_1
X_1423_ clknet_3_3__leaf_clk _0039_ VGND VGND VPWR VPWR net43 sky130_fd_sc_hd__dfxtp_1
X_1354_ core_out\[27\] core_out\[26\] core_out\[25\] core_out\[24\] net52 VGND VGND
+ VPWR VPWR _0666_ sky130_fd_sc_hd__o41a_1
X_1285_ net101 core_out\[17\] net112 _0607_ VGND VGND VPWR VPWR _0066_ sky130_fd_sc_hd__o211a_1
XFILLER_28_309 VGND VGND VPWR VPWR sky130_fd_sc_hd__decap_8
XFILLER_63_161 VGND VGND VPWR VPWR sky130_fd_sc_hd__decap_6
XFILLER_36_397 VGND VGND VPWR VPWR sky130_fd_sc_hd__decap_6
XFILLER_50_29 VPWR VGND VPWR VGND sky130_ef_sc_hd__decap_12
XFILLER_59_27 VPWR VGND VPWR VGND sky130_ef_sc_hd__decap_12
XFILLER_54_183 VPWR VGND VPWR VGND sky130_ef_sc_hd__decap_12
XFILLER_27_375 VGND VGND VPWR VPWR sky130_fd_sc_hd__fill_1
XFILLER_27_364 VGND VGND VPWR VPWR sky130_fd_sc_hd__decap_6
XTAP_TAPCELL_ROW_12_226 VGND VPWR sky130_fd_sc_hd__tapvpwrvgnd_1
XFILLER_24_41 VPWR VGND VPWR VGND sky130_ef_sc_hd__decap_12
XFILLER_24_63 VGND VGND VPWR VPWR sky130_fd_sc_hd__decap_8
XFILLER_40_62 VPWR VGND VPWR VGND sky130_ef_sc_hd__decap_12
XFILLER_6_213 VGND VGND VPWR VPWR sky130_fd_sc_hd__decap_6
XFILLER_10_253 VPWR VGND VPWR VGND sky130_ef_sc_hd__decap_12
XTAP_TAPCELL_ROW_20_281 VGND VPWR sky130_fd_sc_hd__tapvpwrvgnd_1
XFILLER_60_120 VPWR VGND VPWR VGND sky130_ef_sc_hd__decap_12
XFILLER_37_128 VGND VGND VPWR VPWR sky130_fd_sc_hd__decap_8
XFILLER_33_334 VGND VGND VPWR VPWR sky130_fd_sc_hd__fill_2
X_1070_ _0394_ _0399_ _0400_ VGND VGND VPWR VPWR _0401_ sky130_fd_sc_hd__and3_1
XFILLER_60_197 VPWR VGND VPWR VGND sky130_ef_sc_hd__decap_12
XFILLER_60_153 VPWR VGND VPWR VGND sky130_ef_sc_hd__decap_12
X_0854_ core_out\[3\] _0190_ VGND VGND VPWR VPWR _0191_ sky130_fd_sc_hd__nand2_1
XFILLER_33_378 VGND VGND VPWR VPWR sky130_fd_sc_hd__decap_4
X_0923_ net71 net88 VGND VGND VPWR VPWR _0257_ sky130_fd_sc_hd__nand2_1
X_0785_ net151 net105 net58 _0138_ net115 VGND VGND VPWR VPWR _0035_ sky130_fd_sc_hd__o221a_1
XPHY_EDGE_ROW_49_Right_49 VGND VGND VPWR VPWR sky130_fd_sc_hd__decap_3
X_1337_ net103 core_out\[25\] VGND VGND VPWR VPWR _0652_ sky130_fd_sc_hd__nor2_1
XPHY_EDGE_ROW_58_Right_58 VGND VGND VPWR VPWR sky130_fd_sc_hd__decap_3
XFILLER_45_18 VGND VGND VPWR VPWR sky130_fd_sc_hd__decap_8
X_1268_ core_out\[15\] net55 VGND VGND VPWR VPWR _0593_ sky130_fd_sc_hd__and2_4
XFILLER_28_117 VGND VGND VPWR VPWR sky130_fd_sc_hd__fill_2
X_1406_ clknet_3_5__leaf_clk _0022_ VGND VGND VPWR VPWR net24 sky130_fd_sc_hd__dfxtp_1
Xhold19 net20 VGND VGND VPWR VPWR net135 sky130_fd_sc_hd__dlygate4sd3_1
XFILLER_61_39 VPWR VGND VPWR VGND sky130_ef_sc_hd__decap_12
X_1199_ core_out\[12\] _0526_ VGND VGND VPWR VPWR _0527_ sky130_fd_sc_hd__and2_1
XFILLER_24_389 VPWR VGND VPWR VGND sky130_ef_sc_hd__decap_12
XFILLER_3_205 VPWR VGND VPWR VGND sky130_ef_sc_hd__decap_12
XFILLER_59_242 VGND VGND VPWR VPWR sky130_fd_sc_hd__decap_3
XFILLER_3_249 VPWR VGND VPWR VGND sky130_ef_sc_hd__decap_12
XFILLER_10_43 VPWR VGND VPWR VGND sky130_ef_sc_hd__decap_12
XFILLER_35_51 VGND VGND VPWR VPWR sky130_fd_sc_hd__decap_4
XFILLER_42_197 VPWR VGND VPWR VGND sky130_ef_sc_hd__decap_12
XFILLER_42_153 VPWR VGND VPWR VGND sky130_ef_sc_hd__decap_12
X_1122_ _0408_ _0410_ _0450_ VGND VGND VPWR VPWR _0452_ sky130_fd_sc_hd__o21a_1
XTAP_TAPCELL_ROW_48_476 VGND VPWR sky130_fd_sc_hd__tapvpwrvgnd_1
XFILLER_33_153 VGND VGND VPWR VPWR sky130_fd_sc_hd__decap_4
XFILLER_21_337 VPWR VGND VPWR VGND sky130_ef_sc_hd__decap_12
X_1053_ net66 net88 net90 _0081_ VGND VGND VPWR VPWR _0384_ sky130_fd_sc_hd__o2bb2a_1
X_0906_ _0238_ _0239_ _0198_ VGND VGND VPWR VPWR _0241_ sky130_fd_sc_hd__a21o_1
X_0837_ _0154_ _0161_ _0159_ VGND VGND VPWR VPWR _0175_ sky130_fd_sc_hd__a21oi_1
XTAP_TAPCELL_ROW_31_354 VGND VPWR sky130_fd_sc_hd__tapvpwrvgnd_1
X_0699_ net9 _0085_ _0087_ VGND VGND VPWR VPWR _0000_ sky130_fd_sc_hd__nor3_1
X_0768_ core_out\[18\] net61 VGND VGND VPWR VPWR _0130_ sky130_fd_sc_hd__and2_1
XFILLER_56_289 VPWR VGND VPWR VGND sky130_ef_sc_hd__decap_12
XTAP_TAPCELL_ROW_39_410 VGND VPWR sky130_fd_sc_hd__tapvpwrvgnd_1
XFILLER_24_197 VGND VGND VPWR VPWR sky130_fd_sc_hd__decap_6
XFILLER_21_53 VGND VGND VPWR VPWR sky130_fd_sc_hd__decap_3
XFILLER_62_226 VGND VGND VPWR VPWR sky130_fd_sc_hd__decap_8
XFILLER_47_289 VGND VGND VPWR VPWR sky130_fd_sc_hd__decap_4
XFILLER_47_278 VGND VGND VPWR VPWR sky130_fd_sc_hd__fill_2
XTAP_TAPCELL_ROW_45_457 VGND VPWR sky130_fd_sc_hd__tapvpwrvgnd_1
XFILLER_30_112 VGND VGND VPWR VPWR sky130_fd_sc_hd__fill_1
XFILLER_15_131 VGND VGND VPWR VPWR sky130_fd_sc_hd__fill_1
XFILLER_15_142 VPWR VGND VPWR VGND sky130_ef_sc_hd__decap_12
XFILLER_7_55 VGND VGND VPWR VPWR sky130_fd_sc_hd__fill_1
XFILLER_7_385 VGND VGND VPWR VPWR sky130_fd_sc_hd__decap_6
X_1105_ net70 net72 net80 VGND VGND VPWR VPWR _0435_ sky130_fd_sc_hd__nand3_1
XFILLER_61_281 VPWR VGND VPWR VGND sky130_ef_sc_hd__decap_12
X_1036_ _0315_ _0318_ _0364_ _0366_ VGND VGND VPWR VPWR _0368_ sky130_fd_sc_hd__a211o_1
XFILLER_21_156 VGND VGND VPWR VPWR sky130_fd_sc_hd__decap_3
XFILLER_21_167 VGND VGND VPWR VPWR sky130_fd_sc_hd__fill_1
XFILLER_29_223 VGND VGND VPWR VPWR sky130_fd_sc_hd__fill_1
XFILLER_29_201 VGND VGND VPWR VPWR sky130_fd_sc_hd__decap_4
XFILLER_16_53 VPWR VGND VPWR VGND sky130_ef_sc_hd__decap_12
XTAP_TAPCELL_ROW_50_493 VGND VPWR sky130_fd_sc_hd__tapvpwrvgnd_1
XFILLER_32_85 VPWR VGND VPWR VGND sky130_ef_sc_hd__decap_12
XFILLER_32_74 VGND VGND VPWR VPWR sky130_fd_sc_hd__decap_8
XFILLER_32_41 VPWR VGND VPWR VGND sky130_ef_sc_hd__decap_12
XFILLER_4_377 VPWR VGND VPWR VGND sky130_ef_sc_hd__decap_12
XFILLER_4_333 VPWR VGND VPWR VGND sky130_ef_sc_hd__decap_12
XFILLER_57_93 VPWR VGND VPWR VGND sky130_ef_sc_hd__decap_12
XFILLER_35_237 VPWR VGND VPWR VGND sky130_ef_sc_hd__decap_12
XFILLER_7_193 VGND VGND VPWR VPWR sky130_fd_sc_hd__decap_3
XTAP_TAPCELL_ROW_64_585 VGND VPWR sky130_fd_sc_hd__tapvpwrvgnd_1
XFILLER_26_237 VGND VGND VPWR VPWR sky130_fd_sc_hd__fill_1
X_1019_ net77 net81 net79 VGND VGND VPWR VPWR _0351_ sky130_fd_sc_hd__and3_4
XTAP_TAPCELL_ROW_64_596 VGND VPWR sky130_fd_sc_hd__tapvpwrvgnd_1
XFILLER_57_373 VPWR VGND VPWR VGND sky130_ef_sc_hd__decap_12
XFILLER_27_85 VGND VGND VPWR VPWR sky130_fd_sc_hd__decap_3
XFILLER_25_281 VGND VGND VPWR VPWR sky130_fd_sc_hd__decap_8
XFILLER_4_141 VPWR VGND VPWR VGND sky130_ef_sc_hd__decap_12
X_1370_ _0678_ _0679_ VGND VGND VPWR VPWR _0680_ sky130_fd_sc_hd__nor2_1
XTAP_TAPCELL_ROW_18_265 VGND VPWR sky130_fd_sc_hd__tapvpwrvgnd_1
XTAP_TAPCELL_ROW_61_566 VGND VPWR sky130_fd_sc_hd__tapvpwrvgnd_1
XFILLER_31_262 VPWR VGND VPWR VGND sky130_ef_sc_hd__decap_12
XFILLER_54_321 VPWR VGND VPWR VGND sky130_ef_sc_hd__decap_12
XFILLER_48_29 VGND VGND VPWR VPWR sky130_fd_sc_hd__decap_8
XFILLER_48_18 VGND VGND VPWR VPWR sky130_fd_sc_hd__decap_8
XFILLER_54_376 VGND VGND VPWR VPWR sky130_fd_sc_hd__decap_4
XFILLER_54_365 VGND VGND VPWR VPWR sky130_fd_sc_hd__decap_6
Xfanout55 _0591_ VGND VGND VPWR VPWR net55 sky130_fd_sc_hd__buf_12
XTAP_TAPCELL_ROW_1_144 VGND VPWR sky130_fd_sc_hd__tapvpwrvgnd_1
Xfanout99 net104 VGND VGND VPWR VPWR net99 sky130_fd_sc_hd__dlymetal6s2s_1
Xfanout66 net67 VGND VGND VPWR VPWR net66 sky130_fd_sc_hd__clkbuf_2
XTAP_TAPCELL_ROW_9_200 VGND VPWR sky130_fd_sc_hd__tapvpwrvgnd_1
Xfanout88 core_a\[3\] VGND VGND VPWR VPWR net88 sky130_fd_sc_hd__buf_2
Xfanout77 core_b\[1\] VGND VGND VPWR VPWR net77 sky130_fd_sc_hd__buf_6
XFILLER_1_111 VGND VGND VPWR VPWR sky130_fd_sc_hd__fill_1
XFILLER_8_3 VPWR VGND VPWR VGND sky130_ef_sc_hd__decap_12
XFILLER_57_181 VPWR VGND VPWR VGND sky130_ef_sc_hd__decap_12
XFILLER_60_357 VGND VGND VPWR VPWR sky130_fd_sc_hd__decap_6
XFILLER_54_83 VGND VGND VPWR VPWR sky130_fd_sc_hd__fill_1
X_0870_ _0203_ _0204_ _0205_ VGND VGND VPWR VPWR _0206_ sky130_fd_sc_hd__nand3_1
XPHY_EDGE_ROW_41_Left_106 VGND VGND VPWR VPWR sky130_fd_sc_hd__decap_3
XFILLER_9_211 VGND VGND VPWR VPWR sky130_fd_sc_hd__decap_3
XFILLER_9_277 VGND VGND VPWR VPWR sky130_fd_sc_hd__decap_3
XTAP_TAPCELL_ROW_15_246 VGND VPWR sky130_fd_sc_hd__tapvpwrvgnd_1
X_1422_ clknet_3_6__leaf_clk _0038_ VGND VGND VPWR VPWR net41 sky130_fd_sc_hd__dfxtp_1
X_1353_ _0643_ _0645_ _0664_ VGND VGND VPWR VPWR _0665_ sky130_fd_sc_hd__a21oi_2
XPHY_EDGE_ROW_50_Left_115 VGND VGND VPWR VPWR sky130_fd_sc_hd__decap_3
X_1284_ _0604_ _0605_ _0606_ VGND VGND VPWR VPWR _0607_ sky130_fd_sc_hd__o21ai_1
XFILLER_48_181 VPWR VGND VPWR VGND sky130_ef_sc_hd__decap_12
XFILLER_36_321 VPWR VGND VPWR VGND sky130_ef_sc_hd__decap_12
X_0999_ _0287_ _0289_ _0286_ VGND VGND VPWR VPWR _0332_ sky130_fd_sc_hd__a21oi_2
XFILLER_59_39 VPWR VGND VPWR VGND sky130_ef_sc_hd__decap_12
XFILLER_54_162 VGND VGND VPWR VPWR sky130_fd_sc_hd__fill_1
XFILLER_39_192 VPWR VGND VPWR VGND sky130_ef_sc_hd__decap_12
XFILLER_54_195 VGND VGND VPWR VPWR sky130_fd_sc_hd__fill_1
XFILLER_10_221 VPWR VGND VPWR VGND sky130_ef_sc_hd__decap_12
XTAP_TAPCELL_ROW_12_227 VGND VPWR sky130_fd_sc_hd__tapvpwrvgnd_1
XFILLER_40_74 VGND VGND VPWR VPWR sky130_fd_sc_hd__decap_4
XFILLER_10_265 VPWR VGND VPWR VGND sky130_ef_sc_hd__decap_12
XTAP_TAPCELL_ROW_20_282 VGND VPWR sky130_fd_sc_hd__tapvpwrvgnd_1
XFILLER_49_72 VPWR VGND VPWR VGND sky130_ef_sc_hd__decap_12
XFILLER_60_165 VPWR VGND VPWR VGND sky130_ef_sc_hd__decap_12
XFILLER_60_132 VGND VGND VPWR VPWR sky130_fd_sc_hd__decap_8
XFILLER_1_57 VPWR VGND VPWR VGND sky130_ef_sc_hd__decap_12
XFILLER_18_321 VPWR VGND VPWR VGND sky130_ef_sc_hd__decap_12
XFILLER_18_365 VPWR VGND VPWR VGND sky130_ef_sc_hd__decap_12
XFILLER_60_3 VPWR VGND VPWR VGND sky130_ef_sc_hd__decap_12
X_0853_ _0188_ _0189_ VGND VGND VPWR VPWR _0190_ sky130_fd_sc_hd__nor2_1
X_0922_ net69 net92 VGND VGND VPWR VPWR _0256_ sky130_fd_sc_hd__nand2_1
X_0784_ core_out\[26\] net60 VGND VGND VPWR VPWR _0138_ sky130_fd_sc_hd__and2_1
X_1405_ clknet_3_5__leaf_clk _0021_ VGND VGND VPWR VPWR net23 sky130_fd_sc_hd__dfxtp_1
X_1336_ _0649_ _0650_ VGND VGND VPWR VPWR _0651_ sky130_fd_sc_hd__xnor2_1
Xinput1 addr[0] VGND VGND VPWR VPWR net1 sky130_fd_sc_hd__buf_1
X_1267_ core_out\[15\] net55 VGND VGND VPWR VPWR _0592_ sky130_fd_sc_hd__nor2_1
XTAP_TAPCELL_ROW_26_319 VGND VPWR sky130_fd_sc_hd__tapvpwrvgnd_1
X_1198_ _0525_ _0521_ VGND VGND VPWR VPWR _0526_ sky130_fd_sc_hd__xnor2_4
XFILLER_51_198 VGND VGND VPWR VPWR sky130_fd_sc_hd__fill_2
XFILLER_36_195 VGND VGND VPWR VPWR sky130_fd_sc_hd__fill_1
XFILLER_3_217 VGND VGND VPWR VPWR sky130_fd_sc_hd__decap_6
XFILLER_10_33 VGND VGND VPWR VPWR sky130_fd_sc_hd__fill_1
XFILLER_10_55 VPWR VGND VPWR VGND sky130_ef_sc_hd__decap_12
XFILLER_59_298 VPWR VGND VPWR VGND sky130_ef_sc_hd__decap_12
XFILLER_47_405 VGND VGND VPWR VPWR sky130_fd_sc_hd__fill_2
XFILLER_19_53 VGND VGND VPWR VPWR sky130_fd_sc_hd__decap_3
XFILLER_15_335 VGND VGND VPWR VPWR sky130_fd_sc_hd__fill_1
XFILLER_51_51 VGND VGND VPWR VPWR sky130_fd_sc_hd__decap_4
XFILLER_42_165 VGND VGND VPWR VPWR sky130_fd_sc_hd__decap_8
XTAP_TAPCELL_ROW_48_477 VGND VPWR sky130_fd_sc_hd__tapvpwrvgnd_1
X_1121_ _0408_ _0410_ _0450_ VGND VGND VPWR VPWR _0451_ sky130_fd_sc_hd__or3_1
X_1052_ net69 net88 _0348_ _0347_ VGND VGND VPWR VPWR _0383_ sky130_fd_sc_hd__a31o_1
XFILLER_21_305 VPWR VGND VPWR VGND sky130_ef_sc_hd__decap_12
XFILLER_21_349 VPWR VGND VPWR VGND sky130_ef_sc_hd__decap_12
X_0767_ net158 net105 net58 _0129_ net113 VGND VGND VPWR VPWR _0026_ sky130_fd_sc_hd__o221a_1
X_0905_ _0198_ _0238_ _0239_ VGND VGND VPWR VPWR _0240_ sky130_fd_sc_hd__nand3_2
X_0836_ _0172_ _0173_ VGND VGND VPWR VPWR _0174_ sky130_fd_sc_hd__nand2_1
XTAP_TAPCELL_ROW_31_355 VGND VPWR sky130_fd_sc_hd__tapvpwrvgnd_1
XFILLER_56_29 VPWR VGND VPWR VGND sky130_ef_sc_hd__decap_12
XFILLER_56_18 VGND VGND VPWR VPWR sky130_fd_sc_hd__decap_8
X_0698_ _0082_ _0086_ VGND VGND VPWR VPWR _0087_ sky130_fd_sc_hd__or2_1
XFILLER_0_209 VPWR VGND VPWR VGND sky130_ef_sc_hd__decap_12
X_1319_ net102 _0636_ VGND VGND VPWR VPWR _0637_ sky130_fd_sc_hd__nand2_1
XTAP_TAPCELL_ROW_39_411 VGND VPWR sky130_fd_sc_hd__tapvpwrvgnd_1
XFILLER_24_121 VPWR VGND VPWR VGND sky130_ef_sc_hd__decap_12
XFILLER_8_309 VPWR VGND VPWR VGND sky130_ef_sc_hd__decap_12
XFILLER_12_305 VGND VGND VPWR VPWR sky130_fd_sc_hd__decap_3
XFILLER_46_62 VPWR VGND VPWR VGND sky130_ef_sc_hd__decap_12
XTAP_TAPCELL_ROW_45_458 VGND VPWR sky130_fd_sc_hd__tapvpwrvgnd_1
Xmax_cap63 net64 VGND VGND VPWR VPWR net63 sky130_fd_sc_hd__clkbuf_2
XFILLER_15_154 VPWR VGND VPWR VGND sky130_ef_sc_hd__decap_12
XFILLER_62_83 VGND VGND VPWR VPWR sky130_fd_sc_hd__fill_1
XFILLER_11_393 VPWR VGND VPWR VGND sky130_ef_sc_hd__decap_12
XFILLER_23_3 VPWR VGND VPWR VGND sky130_ef_sc_hd__decap_12
XFILLER_53_205 VPWR VGND VPWR VGND sky130_ef_sc_hd__decap_12
X_1035_ _0315_ _0318_ _0364_ _0366_ VGND VGND VPWR VPWR _0367_ sky130_fd_sc_hd__a211oi_1
X_1104_ net70 net72 net80 VGND VGND VPWR VPWR _0434_ sky130_fd_sc_hd__and3_1
XFILLER_61_293 VGND VGND VPWR VPWR sky130_fd_sc_hd__decap_8
XFILLER_21_102 VGND VGND VPWR VPWR sky130_fd_sc_hd__fill_2
XFILLER_21_113 VPWR VGND VPWR VGND sky130_ef_sc_hd__decap_12
X_0819_ net76 net78 net92 net94 VGND VGND VPWR VPWR _0158_ sky130_fd_sc_hd__nand4_1
XFILLER_29_279 VGND VGND VPWR VPWR sky130_fd_sc_hd__fill_1
XFILLER_16_65 VPWR VGND VPWR VGND sky130_ef_sc_hd__decap_12
XFILLER_32_97 VGND VGND VPWR VPWR sky130_fd_sc_hd__decap_8
XFILLER_32_53 VGND VGND VPWR VPWR sky130_fd_sc_hd__decap_4
XFILLER_4_301 VGND VGND VPWR VPWR sky130_fd_sc_hd__decap_6
XFILLER_4_389 VPWR VGND VPWR VGND sky130_ef_sc_hd__decap_12
XFILLER_4_345 VPWR VGND VPWR VGND sky130_ef_sc_hd__decap_12
XFILLER_35_249 VPWR VGND VPWR VGND sky130_ef_sc_hd__decap_12
XFILLER_35_205 VGND VGND VPWR VPWR sky130_fd_sc_hd__fill_2
XPHY_EDGE_ROW_9_Right_9 VGND VGND VPWR VPWR sky130_fd_sc_hd__decap_3
XTAP_TAPCELL_ROW_64_597 VGND VPWR sky130_fd_sc_hd__tapvpwrvgnd_1
XTAP_TAPCELL_ROW_64_586 VGND VPWR sky130_fd_sc_hd__tapvpwrvgnd_1
X_1018_ _0346_ _0349_ VGND VGND VPWR VPWR _0350_ sky130_fd_sc_hd__xnor2_2
XFILLER_1_337 VPWR VGND VPWR VGND sky130_ef_sc_hd__decap_12
XFILLER_57_385 VGND VGND VPWR VPWR sky130_fd_sc_hd__decap_6
XFILLER_4_153 VPWR VGND VPWR VGND sky130_ef_sc_hd__decap_12
XFILLER_48_330 VPWR VGND VPWR VGND sky130_ef_sc_hd__decap_12
XFILLER_4_197 VPWR VGND VPWR VGND sky130_ef_sc_hd__decap_12
XTAP_TAPCELL_ROW_18_266 VGND VPWR sky130_fd_sc_hd__tapvpwrvgnd_1
XTAP_TAPCELL_ROW_61_567 VGND VPWR sky130_fd_sc_hd__tapvpwrvgnd_1
XFILLER_31_274 VGND VGND VPWR VPWR sky130_fd_sc_hd__decap_6
XFILLER_64_29 VPWR VGND VPWR VGND sky130_ef_sc_hd__decap_12
XFILLER_54_333 VPWR VGND VPWR VGND sky130_ef_sc_hd__decap_12
XTAP_TAPCELL_ROW_1_145 VGND VPWR sky130_fd_sc_hd__tapvpwrvgnd_1
XTAP_TAPCELL_ROW_52_501 VGND VPWR sky130_fd_sc_hd__tapvpwrvgnd_1
Xfanout89 core_a\[3\] VGND VGND VPWR VPWR net89 sky130_fd_sc_hd__clkbuf_2
Xfanout78 net79 VGND VGND VPWR VPWR net78 sky130_fd_sc_hd__buf_2
Xfanout67 core_b\[6\] VGND VGND VPWR VPWR net67 sky130_fd_sc_hd__buf_2
XTAP_TAPCELL_ROW_9_201 VGND VPWR sky130_fd_sc_hd__tapvpwrvgnd_1
XFILLER_13_55 VGND VGND VPWR VPWR sky130_fd_sc_hd__fill_1
XFILLER_13_66 VPWR VGND VPWR VGND sky130_ef_sc_hd__decap_12
XFILLER_38_41 VGND VGND VPWR VPWR sky130_fd_sc_hd__fill_2
XFILLER_1_167 VGND VGND VPWR VPWR sky130_fd_sc_hd__fill_1
XFILLER_57_193 VGND VGND VPWR VPWR sky130_fd_sc_hd__decap_6
XFILLER_38_85 VPWR VGND VPWR VGND sky130_ef_sc_hd__decap_12
XFILLER_9_223 VGND VGND VPWR VPWR sky130_fd_sc_hd__fill_1
XFILLER_9_245 VPWR VGND VPWR VGND sky130_ef_sc_hd__decap_12
XTAP_TAPCELL_ROW_15_247 VGND VPWR sky130_fd_sc_hd__tapvpwrvgnd_1
X_1421_ clknet_3_6__leaf_clk _0037_ VGND VGND VPWR VPWR net40 sky130_fd_sc_hd__dfxtp_1
XFILLER_55_6 VPWR VGND VPWR VGND sky130_ef_sc_hd__decap_12
X_1352_ _0642_ _0649_ _0655_ _0660_ VGND VGND VPWR VPWR _0664_ sky130_fd_sc_hd__or4_1
XFILLER_48_193 VGND VGND VPWR VPWR sky130_fd_sc_hd__decap_3
X_1283_ _0605_ _0604_ net101 VGND VGND VPWR VPWR _0606_ sky130_fd_sc_hd__a21boi_1
XFILLER_36_333 VPWR VGND VPWR VGND sky130_ef_sc_hd__decap_12
X_0998_ _0328_ _0329_ core_out\[7\] VGND VGND VPWR VPWR _0331_ sky130_fd_sc_hd__a21oi_1
XFILLER_54_141 VGND VGND VPWR VPWR sky130_fd_sc_hd__fill_2
XFILLER_27_388 VGND VGND VPWR VPWR sky130_fd_sc_hd__decap_4
XFILLER_50_380 VGND VGND VPWR VPWR sky130_fd_sc_hd__decap_8
XFILLER_10_233 VPWR VGND VPWR VGND sky130_ef_sc_hd__decap_12
XFILLER_10_277 VPWR VGND VPWR VGND sky130_ef_sc_hd__decap_12
XTAP_TAPCELL_ROW_20_283 VGND VPWR sky130_fd_sc_hd__tapvpwrvgnd_1
XFILLER_49_84 VPWR VGND VPWR VGND sky130_ef_sc_hd__decap_12
XFILLER_1_69 VPWR VGND VPWR VGND sky130_ef_sc_hd__decap_12
XFILLER_18_333 VPWR VGND VPWR VGND sky130_ef_sc_hd__decap_12
XFILLER_45_152 VPWR VGND VPWR VGND sky130_ef_sc_hd__decap_12
X_0921_ _0253_ _0254_ VGND VGND VPWR VPWR _0255_ sky130_fd_sc_hd__nor2_1
XFILLER_18_377 VPWR VGND VPWR VGND sky130_ef_sc_hd__decap_12
XPHY_EDGE_ROW_23_Left_88 VGND VGND VPWR VPWR sky130_fd_sc_hd__decap_3
X_0783_ net157 net105 net57 _0137_ net112 VGND VGND VPWR VPWR _0034_ sky130_fd_sc_hd__o221a_1
XFILLER_53_3 VGND VGND VPWR VPWR sky130_fd_sc_hd__decap_3
X_0852_ _0186_ _0187_ _0169_ VGND VGND VPWR VPWR _0189_ sky130_fd_sc_hd__a21oi_1
XFILLER_41_380 VPWR VGND VPWR VGND sky130_ef_sc_hd__decap_12
X_1335_ core_out\[24\] net53 _0646_ VGND VGND VPWR VPWR _0650_ sky130_fd_sc_hd__a21boi_1
X_1404_ clknet_3_5__leaf_clk _0020_ VGND VGND VPWR VPWR net22 sky130_fd_sc_hd__dfxtp_1
XFILLER_5_281 VPWR VGND VPWR VGND sky130_ef_sc_hd__decap_12
Xinput2 addr[1] VGND VGND VPWR VPWR net2 sky130_fd_sc_hd__clkbuf_1
XFILLER_36_174 VGND VGND VPWR VPWR sky130_fd_sc_hd__decap_3
XFILLER_36_141 VGND VGND VPWR VPWR sky130_fd_sc_hd__decap_8
X_1266_ _0570_ _0571_ _0573_ _0590_ VGND VGND VPWR VPWR _0591_ sky130_fd_sc_hd__o211a_4
X_1197_ _0522_ net122 VGND VGND VPWR VPWR _0525_ sky130_fd_sc_hd__nand2_4
XFILLER_51_177 VGND VGND VPWR VPWR sky130_fd_sc_hd__fill_2
XFILLER_51_144 VGND VGND VPWR VPWR sky130_fd_sc_hd__decap_8
XTAP_TAPCELL_ROW_34_375 VGND VPWR sky130_fd_sc_hd__tapvpwrvgnd_1
XFILLER_10_67 VPWR VGND VPWR VGND sky130_ef_sc_hd__decap_12
XFILLER_59_222 VGND VGND VPWR VPWR sky130_fd_sc_hd__fill_2
XFILLER_19_32 VGND VGND VPWR VPWR sky130_fd_sc_hd__decap_4
XFILLER_19_65 VGND VGND VPWR VPWR sky130_fd_sc_hd__fill_2
XFILLER_42_122 VGND VGND VPWR VPWR sky130_fd_sc_hd__decap_3
XFILLER_30_317 VGND VGND VPWR VPWR sky130_fd_sc_hd__fill_2
XFILLER_30_306 VGND VGND VPWR VPWR sky130_fd_sc_hd__fill_2
XFILLER_27_152 VPWR VGND VPWR VGND sky130_ef_sc_hd__decap_12
XFILLER_51_41 VGND VGND VPWR VPWR sky130_fd_sc_hd__fill_2
XFILLER_23_391 VGND VGND VPWR VPWR sky130_fd_sc_hd__fill_1
XFILLER_2_251 VGND VGND VPWR VPWR sky130_fd_sc_hd__fill_1
XTAP_TAPCELL_ROW_48_478 VGND VPWR sky130_fd_sc_hd__tapvpwrvgnd_1
X_1051_ _0377_ _0379_ _0376_ VGND VGND VPWR VPWR _0382_ sky130_fd_sc_hd__a21oi_2
X_1120_ _0423_ _0448_ VGND VGND VPWR VPWR _0450_ sky130_fd_sc_hd__xnor2_1
X_0904_ _0235_ _0236_ _0237_ VGND VGND VPWR VPWR _0239_ sky130_fd_sc_hd__a21o_1
XTAP_TAPCELL_ROW_31_356 VGND VPWR sky130_fd_sc_hd__tapvpwrvgnd_1
XFILLER_21_317 VPWR VGND VPWR VGND sky130_ef_sc_hd__decap_12
X_0697_ net6 net5 net8 net7 VGND VGND VPWR VPWR _0086_ sky130_fd_sc_hd__or4_1
X_0766_ core_out\[17\] net60 VGND VGND VPWR VPWR _0129_ sky130_fd_sc_hd__and2_1
X_0835_ core_out\[2\] _0171_ VGND VGND VPWR VPWR _0173_ sky130_fd_sc_hd__or2_1
X_1318_ _0633_ _0635_ VGND VGND VPWR VPWR _0636_ sky130_fd_sc_hd__xnor2_1
XTAP_TAPCELL_ROW_39_412 VGND VPWR sky130_fd_sc_hd__tapvpwrvgnd_1
X_1249_ core_out\[14\] _0574_ VGND VGND VPWR VPWR _0575_ sky130_fd_sc_hd__nand2_1
XFILLER_24_133 VGND VGND VPWR VPWR sky130_fd_sc_hd__decap_6
XFILLER_47_225 VPWR VGND VPWR VGND sky130_ef_sc_hd__decap_12
XFILLER_46_85 VPWR VGND VPWR VGND sky130_ef_sc_hd__decap_12
XFILLER_46_74 VGND VGND VPWR VPWR sky130_fd_sc_hd__decap_3
Xmax_cap64 _0089_ VGND VGND VPWR VPWR net64 sky130_fd_sc_hd__clkbuf_2
XFILLER_15_166 VGND VGND VPWR VPWR sky130_fd_sc_hd__fill_2
XFILLER_7_57 VPWR VGND VPWR VGND sky130_ef_sc_hd__decap_12
XFILLER_11_361 VPWR VGND VPWR VGND sky130_ef_sc_hd__decap_12
XFILLER_16_3 VPWR VGND VPWR VGND sky130_ef_sc_hd__decap_12
XFILLER_61_261 VGND VGND VPWR VPWR sky130_fd_sc_hd__decap_4
XFILLER_53_228 VPWR VGND VPWR VGND sky130_ef_sc_hd__decap_12
XFILLER_53_217 VGND VGND VPWR VPWR sky130_fd_sc_hd__decap_6
XFILLER_38_269 VPWR VGND VPWR VGND sky130_ef_sc_hd__decap_12
X_1034_ _0362_ _0363_ _0345_ VGND VGND VPWR VPWR _0366_ sky130_fd_sc_hd__a21oi_1
X_1103_ net72 net80 net82 net70 VGND VGND VPWR VPWR _0433_ sky130_fd_sc_hd__a22o_1
XPHY_EDGE_ROW_26_Left_91 VGND VGND VPWR VPWR sky130_fd_sc_hd__decap_3
XFILLER_21_125 VGND VGND VPWR VPWR sky130_fd_sc_hd__decap_4
XFILLER_21_136 VPWR VGND VPWR VGND sky130_ef_sc_hd__decap_12
XFILLER_21_169 VPWR VGND VPWR VGND sky130_ef_sc_hd__decap_12
X_0749_ net150 net105 net58 _0120_ net112 VGND VGND VPWR VPWR _0017_ sky130_fd_sc_hd__o221a_1
X_0818_ net76 net78 net92 net94 VGND VGND VPWR VPWR _0157_ sky130_fd_sc_hd__and4_1
XPHY_EDGE_ROW_10_Left_75 VGND VGND VPWR VPWR sky130_fd_sc_hd__decap_3
XFILLER_44_217 VGND VGND VPWR VPWR sky130_fd_sc_hd__decap_4
XFILLER_29_225 VGND VGND VPWR VPWR sky130_fd_sc_hd__decap_3
XFILLER_44_239 VGND VGND VPWR VPWR sky130_fd_sc_hd__decap_6
XFILLER_32_21 VGND VGND VPWR VPWR sky130_fd_sc_hd__decap_6
XFILLER_16_77 VGND VGND VPWR VPWR sky130_fd_sc_hd__fill_1
XFILLER_4_357 VGND VGND VPWR VPWR sky130_fd_sc_hd__decap_6
XFILLER_50_209 VPWR VGND VPWR VGND sky130_ef_sc_hd__decap_12
XFILLER_43_261 VPWR VGND VPWR VGND sky130_ef_sc_hd__decap_12
XFILLER_58_309 VPWR VGND VPWR VGND sky130_ef_sc_hd__decap_12
XTAP_TAPCELL_ROW_64_598 VGND VPWR sky130_fd_sc_hd__tapvpwrvgnd_1
XTAP_TAPCELL_ROW_64_587 VGND VPWR sky130_fd_sc_hd__tapvpwrvgnd_1
XFILLER_34_250 VGND VGND VPWR VPWR sky130_fd_sc_hd__fill_2
X_1017_ _0347_ _0348_ VGND VGND VPWR VPWR _0349_ sky130_fd_sc_hd__and2b_1
XFILLER_22_401 VGND VGND VPWR VPWR sky130_fd_sc_hd__decap_6
XFILLER_1_349 VPWR VGND VPWR VGND sky130_ef_sc_hd__decap_12
XFILLER_1_305 VPWR VGND VPWR VGND sky130_ef_sc_hd__decap_12
XTAP_TAPCELL_ROW_4_165 VGND VPWR sky130_fd_sc_hd__tapvpwrvgnd_1
XFILLER_17_239 VPWR VGND VPWR VGND sky130_ef_sc_hd__decap_12
XFILLER_43_97 VGND VGND VPWR VPWR sky130_fd_sc_hd__decap_8
XFILLER_40_253 VGND VGND VPWR VPWR sky130_fd_sc_hd__decap_6
XFILLER_9_405 VGND VGND VPWR VPWR sky130_fd_sc_hd__fill_2
XFILLER_4_165 VPWR VGND VPWR VGND sky130_ef_sc_hd__decap_12
XFILLER_4_121 VPWR VGND VPWR VGND sky130_ef_sc_hd__decap_12
XFILLER_48_342 VPWR VGND VPWR VGND sky130_ef_sc_hd__decap_12
XFILLER_0_393 VPWR VGND VPWR VGND sky130_ef_sc_hd__decap_12
XTAP_TAPCELL_ROW_61_568 VGND VPWR sky130_fd_sc_hd__tapvpwrvgnd_1
XTAP_TAPCELL_ROW_18_267 VGND VPWR sky130_fd_sc_hd__tapvpwrvgnd_1
XFILLER_23_209 VPWR VGND VPWR VGND sky130_ef_sc_hd__decap_12
XFILLER_54_345 VPWR VGND VPWR VGND sky130_ef_sc_hd__decap_12
XFILLER_54_301 VGND VGND VPWR VPWR sky130_fd_sc_hd__decap_6
XFILLER_39_386 VGND VGND VPWR VPWR sky130_fd_sc_hd__decap_6
XTAP_TAPCELL_ROW_1_146 VGND VPWR sky130_fd_sc_hd__tapvpwrvgnd_1
XFILLER_14_209 VPWR VGND VPWR VGND sky130_ef_sc_hd__decap_12
XTAP_TAPCELL_ROW_52_502 VGND VPWR sky130_fd_sc_hd__tapvpwrvgnd_1
Xfanout57 net59 VGND VGND VPWR VPWR net57 sky130_fd_sc_hd__clkbuf_4
Xfanout68 net69 VGND VGND VPWR VPWR net68 sky130_fd_sc_hd__buf_2
XFILLER_22_253 VPWR VGND VPWR VGND sky130_ef_sc_hd__decap_12
Xfanout79 core_b\[0\] VGND VGND VPWR VPWR net79 sky130_fd_sc_hd__buf_8
XFILLER_1_113 VPWR VGND VPWR VGND sky130_ef_sc_hd__decap_12
XTAP_TAPCELL_ROW_9_202 VGND VPWR sky130_fd_sc_hd__tapvpwrvgnd_1
XFILLER_13_78 VPWR VGND VPWR VGND sky130_ef_sc_hd__decap_12
XFILLER_57_161 VGND VGND VPWR VPWR sky130_fd_sc_hd__decap_6
XFILLER_38_97 VPWR VGND VPWR VGND sky130_ef_sc_hd__decap_12
XFILLER_54_85 VPWR VGND VPWR VGND sky130_ef_sc_hd__decap_12
XFILLER_54_41 VPWR VGND VPWR VGND sky130_ef_sc_hd__decap_12
XTAP_TAPCELL_ROW_15_248 VGND VPWR sky130_fd_sc_hd__tapvpwrvgnd_1
XFILLER_9_257 VPWR VGND VPWR VGND sky130_ef_sc_hd__decap_12
X_1420_ clknet_3_6__leaf_clk _0036_ VGND VGND VPWR VPWR net39 sky130_fd_sc_hd__dfxtp_1
X_1351_ _0662_ net100 _0663_ net9 VGND VGND VPWR VPWR _0076_ sky130_fd_sc_hd__a211oi_1
XFILLER_48_6 VPWR VGND VPWR VGND sky130_ef_sc_hd__decap_12
X_1282_ core_out\[16\] net123 _0601_ VGND VGND VPWR VPWR _0605_ sky130_fd_sc_hd__a21bo_1
XFILLER_36_345 VPWR VGND VPWR VGND sky130_ef_sc_hd__decap_12
XFILLER_51_337 VPWR VGND VPWR VGND sky130_ef_sc_hd__decap_12
X_0997_ core_out\[7\] _0328_ _0329_ VGND VGND VPWR VPWR _0330_ sky130_fd_sc_hd__and3_1
XFILLER_27_301 VGND VGND VPWR VPWR sky130_fd_sc_hd__decap_3
XFILLER_24_11 VGND VGND VPWR VPWR sky130_fd_sc_hd__decap_4
XFILLER_10_245 VGND VGND VPWR VPWR sky130_fd_sc_hd__decap_6
XFILLER_10_289 VPWR VGND VPWR VGND sky130_ef_sc_hd__decap_12
XFILLER_49_96 VPWR VGND VPWR VGND sky130_ef_sc_hd__decap_12
XFILLER_45_131 VPWR VGND VPWR VGND sky130_ef_sc_hd__decap_12
XFILLER_1_15 VPWR VGND VPWR VGND sky130_ef_sc_hd__decap_12
XFILLER_18_301 VGND VGND VPWR VPWR sky130_fd_sc_hd__decap_6
XFILLER_18_345 VPWR VGND VPWR VGND sky130_ef_sc_hd__decap_12
XFILLER_60_101 VGND VGND VPWR VPWR sky130_fd_sc_hd__fill_1
XFILLER_45_164 VGND VGND VPWR VPWR sky130_fd_sc_hd__decap_4
X_0920_ net67 net95 _0221_ _0225_ VGND VGND VPWR VPWR _0254_ sky130_fd_sc_hd__a211oi_1
XFILLER_33_337 VPWR VGND VPWR VGND sky130_ef_sc_hd__decap_12
XFILLER_18_389 VPWR VGND VPWR VGND sky130_ef_sc_hd__decap_12
X_0782_ core_out\[25\] net60 VGND VGND VPWR VPWR _0137_ sky130_fd_sc_hd__and2_1
X_0851_ _0169_ _0186_ _0187_ VGND VGND VPWR VPWR _0188_ sky130_fd_sc_hd__and3_1
X_1334_ core_out\[25\] net53 VGND VGND VPWR VPWR _0649_ sky130_fd_sc_hd__xnor2_1
X_1403_ clknet_3_5__leaf_clk _0019_ VGND VGND VPWR VPWR net21 sky130_fd_sc_hd__dfxtp_1
XFILLER_28_109 VGND VGND VPWR VPWR sky130_fd_sc_hd__decap_8
XFILLER_5_293 VPWR VGND VPWR VGND sky130_ef_sc_hd__decap_12
X_1265_ _0586_ _0589_ VGND VGND VPWR VPWR _0590_ sky130_fd_sc_hd__xor2_1
XPHY_EDGE_ROW_18_Right_18 VGND VGND VPWR VPWR sky130_fd_sc_hd__decap_3
XFILLER_51_101 VGND VGND VPWR VPWR sky130_fd_sc_hd__decap_8
Xinput3 addr[2] VGND VGND VPWR VPWR net3 sky130_fd_sc_hd__clkbuf_1
XFILLER_36_197 VGND VGND VPWR VPWR sky130_fd_sc_hd__decap_4
XFILLER_36_131 VGND VGND VPWR VPWR sky130_fd_sc_hd__decap_8
XFILLER_36_120 VGND VGND VPWR VPWR sky130_fd_sc_hd__fill_2
X_1196_ _0455_ _0336_ _0456_ _0523_ VGND VGND VPWR VPWR _0524_ sky130_fd_sc_hd__a211o_1
XPHY_EDGE_ROW_27_Right_27 VGND VGND VPWR VPWR sky130_fd_sc_hd__decap_3
XTAP_TAPCELL_ROW_34_376 VGND VPWR sky130_fd_sc_hd__tapvpwrvgnd_1
XPHY_EDGE_ROW_36_Right_36 VGND VGND VPWR VPWR sky130_fd_sc_hd__decap_3
XFILLER_10_79 VGND VGND VPWR VPWR sky130_fd_sc_hd__decap_4
XFILLER_59_289 VGND VGND VPWR VPWR sky130_fd_sc_hd__decap_3
XFILLER_59_234 VGND VGND VPWR VPWR sky130_fd_sc_hd__decap_8
XPHY_EDGE_ROW_45_Right_45 VGND VGND VPWR VPWR sky130_fd_sc_hd__decap_3
XFILLER_27_164 VGND VGND VPWR VPWR sky130_fd_sc_hd__decap_4
XFILLER_15_337 VPWR VGND VPWR VGND sky130_ef_sc_hd__decap_12
XPHY_EDGE_ROW_54_Right_54 VGND VGND VPWR VPWR sky130_fd_sc_hd__decap_3
XPHY_EDGE_ROW_63_Right_63 VGND VGND VPWR VPWR sky130_fd_sc_hd__decap_3
XTAP_TAPCELL_ROW_48_479 VGND VPWR sky130_fd_sc_hd__tapvpwrvgnd_1
X_1050_ net112 _0381_ VGND VGND VPWR VPWR _0057_ sky130_fd_sc_hd__and2_1
XPHY_EDGE_ROW_38_Left_103 VGND VGND VPWR VPWR sky130_fd_sc_hd__decap_3
XFILLER_33_145 VGND VGND VPWR VPWR sky130_fd_sc_hd__fill_1
XFILLER_18_197 VGND VGND VPWR VPWR sky130_fd_sc_hd__decap_6
X_0903_ _0235_ _0236_ _0237_ VGND VGND VPWR VPWR _0238_ sky130_fd_sc_hd__nand3_2
X_0834_ core_out\[2\] _0171_ VGND VGND VPWR VPWR _0172_ sky130_fd_sc_hd__nand2_1
XTAP_TAPCELL_ROW_31_357 VGND VPWR sky130_fd_sc_hd__tapvpwrvgnd_1
XFILLER_21_329 VGND VGND VPWR VPWR sky130_fd_sc_hd__decap_6
X_0696_ net2 net1 net3 _0084_ VGND VGND VPWR VPWR _0085_ sky130_fd_sc_hd__or4b_1
XPHY_EDGE_ROW_47_Left_112 VGND VGND VPWR VPWR sky130_fd_sc_hd__decap_3
X_0765_ net145 net106 net57 _0128_ net113 VGND VGND VPWR VPWR _0025_ sky130_fd_sc_hd__o221a_1
X_1317_ core_out\[21\] net54 _0624_ _0634_ VGND VGND VPWR VPWR _0635_ sky130_fd_sc_hd__a2bb2o_4
XTAP_TAPCELL_ROW_39_413 VGND VPWR sky130_fd_sc_hd__tapvpwrvgnd_1
X_1248_ _0560_ _0572_ VGND VGND VPWR VPWR _0574_ sky130_fd_sc_hd__xor2_1
XFILLER_64_281 VPWR VGND VPWR VGND sky130_ef_sc_hd__decap_12
XPHY_EDGE_ROW_56_Left_121 VGND VGND VPWR VPWR sky130_fd_sc_hd__decap_3
X_1179_ net85 net82 net66 net65 VGND VGND VPWR VPWR _0507_ sky130_fd_sc_hd__and4b_1
XFILLER_24_189 VGND VGND VPWR VPWR sky130_fd_sc_hd__decap_6
XFILLER_21_34 VGND VGND VPWR VPWR sky130_fd_sc_hd__fill_2
XFILLER_21_45 VGND VGND VPWR VPWR sky130_fd_sc_hd__decap_8
XFILLER_21_67 VPWR VGND VPWR VGND sky130_ef_sc_hd__decap_12
XFILLER_55_281 VGND VGND VPWR VPWR sky130_fd_sc_hd__decap_8
XFILLER_47_237 VPWR VGND VPWR VGND sky130_ef_sc_hd__decap_12
XFILLER_46_97 VGND VGND VPWR VPWR sky130_fd_sc_hd__fill_2
XFILLER_62_85 VPWR VGND VPWR VGND sky130_ef_sc_hd__decap_12
XFILLER_62_41 VPWR VGND VPWR VGND sky130_ef_sc_hd__decap_12
XFILLER_30_126 VGND VGND VPWR VPWR sky130_fd_sc_hd__decap_3
XFILLER_11_373 VPWR VGND VPWR VGND sky130_ef_sc_hd__decap_12
XFILLER_7_69 VGND VGND VPWR VPWR sky130_fd_sc_hd__decap_3
X_1102_ _0398_ _0431_ VGND VGND VPWR VPWR _0432_ sky130_fd_sc_hd__nor2_2
X_1033_ _0345_ _0362_ _0363_ VGND VGND VPWR VPWR _0365_ sky130_fd_sc_hd__nand3_1
X_0817_ net78 net92 net94 net76 VGND VGND VPWR VPWR _0156_ sky130_fd_sc_hd__a22o_1
XFILLER_21_148 VGND VGND VPWR VPWR sky130_fd_sc_hd__decap_8
X_0748_ core_out\[8\] net60 VGND VGND VPWR VPWR _0120_ sky130_fd_sc_hd__and2_1
XFILLER_37_281 VPWR VGND VPWR VGND sky130_ef_sc_hd__decap_12
XFILLER_37_270 VGND VGND VPWR VPWR sky130_fd_sc_hd__decap_8
XFILLER_29_215 VGND VGND VPWR VPWR sky130_fd_sc_hd__decap_8
XFILLER_32_11 VGND VGND VPWR VPWR sky130_fd_sc_hd__fill_2
XPHY_EDGE_ROW_0_Right_0 VGND VGND VPWR VPWR sky130_fd_sc_hd__decap_3
XFILLER_57_30 VPWR VGND VPWR VGND sky130_ef_sc_hd__decap_12
XFILLER_43_273 VGND VGND VPWR VPWR sky130_fd_sc_hd__decap_6
XTAP_TAPCELL_ROW_41_430 VGND VPWR sky130_fd_sc_hd__tapvpwrvgnd_1
XFILLER_7_185 VGND VGND VPWR VPWR sky130_fd_sc_hd__decap_8
XFILLER_3_391 VGND VGND VPWR VPWR sky130_fd_sc_hd__fill_1
XTAP_TAPCELL_ROW_64_588 VGND VPWR sky130_fd_sc_hd__tapvpwrvgnd_1
X_1016_ net73 net84 net86 net70 VGND VGND VPWR VPWR _0348_ sky130_fd_sc_hd__a22o_1
XTAP_TAPCELL_ROW_4_166 VGND VPWR sky130_fd_sc_hd__tapvpwrvgnd_1
XFILLER_1_317 VPWR VGND VPWR VGND sky130_ef_sc_hd__decap_12
XTAP_TAPCELL_ROW_55_522 VGND VPWR sky130_fd_sc_hd__tapvpwrvgnd_1
XFILLER_43_21 VGND VGND VPWR VPWR sky130_fd_sc_hd__decap_8
XFILLER_27_77 VGND VGND VPWR VPWR sky130_fd_sc_hd__decap_8
XFILLER_27_44 VGND VGND VPWR VPWR sky130_fd_sc_hd__decap_4
XFILLER_25_251 VPWR VGND VPWR VGND sky130_ef_sc_hd__decap_12
XFILLER_40_287 VPWR VGND VPWR VGND sky130_ef_sc_hd__decap_12
XFILLER_4_177 VPWR VGND VPWR VGND sky130_ef_sc_hd__decap_12
XFILLER_4_133 VGND VGND VPWR VPWR sky130_fd_sc_hd__decap_6
XFILLER_4_15 VPWR VGND VPWR VGND sky130_ef_sc_hd__decap_12
XFILLER_63_335 VGND VGND VPWR VPWR sky130_fd_sc_hd__fill_1
XFILLER_48_365 VGND VGND VPWR VPWR sky130_fd_sc_hd__decap_6
XFILLER_48_354 VGND VGND VPWR VPWR sky130_fd_sc_hd__fill_1
XFILLER_0_361 VGND VGND VPWR VPWR sky130_fd_sc_hd__decap_3
XTAP_TAPCELL_ROW_61_569 VGND VPWR sky130_fd_sc_hd__tapvpwrvgnd_1
XFILLER_16_251 VGND VGND VPWR VPWR sky130_fd_sc_hd__fill_1
XTAP_TAPCELL_ROW_18_268 VGND VPWR sky130_fd_sc_hd__tapvpwrvgnd_1
XFILLER_31_298 VGND VGND VPWR VPWR sky130_fd_sc_hd__decap_3
XFILLER_54_357 VGND VGND VPWR VPWR sky130_fd_sc_hd__decap_6
XTAP_TAPCELL_ROW_52_503 VGND VPWR sky130_fd_sc_hd__tapvpwrvgnd_1
XTAP_TAPCELL_ROW_1_147 VGND VPWR sky130_fd_sc_hd__tapvpwrvgnd_1
Xfanout58 net59 VGND VGND VPWR VPWR net58 sky130_fd_sc_hd__buf_2
Xfanout69 core_b\[5\] VGND VGND VPWR VPWR net69 sky130_fd_sc_hd__buf_2
XFILLER_22_232 VPWR VGND VPWR VGND sky130_ef_sc_hd__decap_12
XFILLER_22_265 VPWR VGND VPWR VGND sky130_ef_sc_hd__decap_12
XFILLER_1_125 VPWR VGND VPWR VGND sky130_ef_sc_hd__decap_12
XTAP_TAPCELL_ROW_9_203 VGND VPWR sky130_fd_sc_hd__tapvpwrvgnd_1
XFILLER_1_169 VPWR VGND VPWR VGND sky130_ef_sc_hd__decap_12
XFILLER_60_305 VGND VGND VPWR VPWR sky130_fd_sc_hd__decap_3
XFILLER_54_97 VPWR VGND VPWR VGND sky130_ef_sc_hd__decap_12
XFILLER_54_53 VPWR VGND VPWR VGND sky130_ef_sc_hd__decap_12
XFILLER_9_203 VGND VGND VPWR VPWR sky130_fd_sc_hd__decap_8
XFILLER_13_232 VGND VGND VPWR VPWR sky130_fd_sc_hd__decap_4
XFILLER_13_243 VPWR VGND VPWR VGND sky130_ef_sc_hd__decap_12
XFILLER_9_269 VGND VGND VPWR VPWR sky130_fd_sc_hd__decap_8
X_1350_ net100 net184 VGND VGND VPWR VPWR _0663_ sky130_fd_sc_hd__nor2_1
X_1281_ core_out\[17\] net55 VGND VGND VPWR VPWR _0604_ sky130_fd_sc_hd__xnor2_4
XFILLER_51_316 VPWR VGND VPWR VGND sky130_ef_sc_hd__decap_12
XFILLER_36_357 VGND VGND VPWR VPWR sky130_fd_sc_hd__decap_6
XFILLER_51_349 VPWR VGND VPWR VGND sky130_ef_sc_hd__decap_12
X_0996_ _0326_ _0327_ _0292_ VGND VGND VPWR VPWR _0329_ sky130_fd_sc_hd__a21o_1
XFILLER_59_405 VGND VGND VPWR VPWR sky130_fd_sc_hd__fill_2
XFILLER_54_121 VPWR VGND VPWR VGND sky130_ef_sc_hd__decap_12
XFILLER_27_335 VGND VGND VPWR VPWR sky130_fd_sc_hd__fill_1
XFILLER_54_154 VGND VGND VPWR VPWR sky130_fd_sc_hd__decap_8
XTAP_TAPCELL_ROW_37_396 VGND VPWR sky130_fd_sc_hd__tapvpwrvgnd_1
XFILLER_50_371 VGND VGND VPWR VPWR sky130_fd_sc_hd__fill_1
XFILLER_24_89 VGND VGND VPWR VPWR sky130_fd_sc_hd__fill_1
XFILLER_6_3 VPWR VGND VPWR VGND sky130_ef_sc_hd__decap_12
XFILLER_2_401 VGND VGND VPWR VPWR sky130_fd_sc_hd__decap_6
XFILLER_45_143 VGND VGND VPWR VPWR sky130_fd_sc_hd__fill_1
XFILLER_33_305 VPWR VGND VPWR VGND sky130_ef_sc_hd__decap_12
XFILLER_1_27 VPWR VGND VPWR VGND sky130_ef_sc_hd__decap_12
XFILLER_18_357 VGND VGND VPWR VPWR sky130_fd_sc_hd__decap_6
X_0850_ net73 net94 _0184_ _0185_ VGND VGND VPWR VPWR _0187_ sky130_fd_sc_hd__a22o_1
XFILLER_41_393 VGND VGND VPWR VPWR sky130_fd_sc_hd__fill_2
XFILLER_41_360 VPWR VGND VPWR VGND sky130_ef_sc_hd__decap_12
XFILLER_33_349 VPWR VGND VPWR VGND sky130_ef_sc_hd__decap_12
X_0781_ net160 _0101_ net58 _0136_ net114 VGND VGND VPWR VPWR _0033_ sky130_fd_sc_hd__o221a_1
X_1402_ clknet_3_4__leaf_clk _0018_ VGND VGND VPWR VPWR net51 sky130_fd_sc_hd__dfxtp_1
XFILLER_5_261 VPWR VGND VPWR VGND sky130_ef_sc_hd__decap_12
Xinput4 addr[3] VGND VGND VPWR VPWR net4 sky130_fd_sc_hd__clkbuf_1
X_1333_ net101 net180 net112 _0648_ VGND VGND VPWR VPWR _0073_ sky130_fd_sc_hd__o211a_1
X_1264_ _0564_ _0587_ _0588_ VGND VGND VPWR VPWR _0589_ sky130_fd_sc_hd__a21bo_1
XFILLER_51_113 VGND VGND VPWR VPWR sky130_fd_sc_hd__decap_6
XFILLER_36_187 VGND VGND VPWR VPWR sky130_fd_sc_hd__decap_8
XFILLER_36_154 VPWR VGND VPWR VGND sky130_ef_sc_hd__decap_12
X_1195_ _0452_ _0488_ _0487_ VGND VGND VPWR VPWR _0523_ sky130_fd_sc_hd__a21o_1
XTAP_TAPCELL_ROW_34_377 VGND VPWR sky130_fd_sc_hd__tapvpwrvgnd_1
X_0979_ _0305_ _0310_ _0311_ VGND VGND VPWR VPWR _0312_ sky130_fd_sc_hd__nand3_1
XFILLER_42_102 VPWR VGND VPWR VGND sky130_ef_sc_hd__decap_12
XFILLER_15_305 VPWR VGND VPWR VGND sky130_ef_sc_hd__decap_12
XFILLER_19_45 VGND VGND VPWR VPWR sky130_fd_sc_hd__decap_8
XFILLER_50_190 VGND VGND VPWR VPWR sky130_fd_sc_hd__decap_6
XFILLER_35_55 VGND VGND VPWR VPWR sky130_fd_sc_hd__fill_1
XFILLER_27_187 VPWR VGND VPWR VGND sky130_ef_sc_hd__decap_12
XFILLER_15_349 VPWR VGND VPWR VGND sky130_ef_sc_hd__decap_12
XFILLER_23_393 VPWR VGND VPWR VGND sky130_ef_sc_hd__decap_12
XFILLER_51_65 VGND VGND VPWR VPWR sky130_fd_sc_hd__decap_3
XFILLER_2_253 VPWR VGND VPWR VGND sky130_ef_sc_hd__decap_12
XFILLER_33_157 VGND VGND VPWR VPWR sky130_fd_sc_hd__fill_1
XFILLER_33_113 VGND VGND VPWR VPWR sky130_fd_sc_hd__decap_4
XFILLER_18_110 VPWR VGND VPWR VGND sky130_ef_sc_hd__decap_12
XFILLER_18_154 VPWR VGND VPWR VGND sky130_ef_sc_hd__decap_12
X_0902_ _0199_ _0207_ _0206_ VGND VGND VPWR VPWR _0237_ sky130_fd_sc_hd__a21bo_1
X_0833_ _0169_ _0170_ VGND VGND VPWR VPWR _0171_ sky130_fd_sc_hd__nor2_1
XTAP_TAPCELL_ROW_31_358 VGND VPWR sky130_fd_sc_hd__tapvpwrvgnd_1
X_0764_ core_out\[16\] net61 VGND VGND VPWR VPWR _0128_ sky130_fd_sc_hd__and2_1
X_0695_ net11 net10 net19 VGND VGND VPWR VPWR _0084_ sky130_fd_sc_hd__and3_1
XFILLER_56_227 VPWR VGND VPWR VGND sky130_ef_sc_hd__decap_12
X_1316_ core_out\[21\] core_out\[20\] net54 VGND VGND VPWR VPWR _0634_ sky130_fd_sc_hd__o21ai_1
XTAP_TAPCELL_ROW_39_414 VGND VPWR sky130_fd_sc_hd__tapvpwrvgnd_1
X_1178_ net66 net82 net84 _0081_ VGND VGND VPWR VPWR _0506_ sky130_fd_sc_hd__o2bb2a_1
X_1247_ _0560_ _0572_ VGND VGND VPWR VPWR _0573_ sky130_fd_sc_hd__nand2_2
XFILLER_64_293 VGND VGND VPWR VPWR sky130_fd_sc_hd__decap_4
XFILLER_20_363 VGND VGND VPWR VPWR sky130_fd_sc_hd__fill_1
XFILLER_21_57 VGND VGND VPWR VPWR sky130_fd_sc_hd__fill_1
XFILLER_21_79 VPWR VGND VPWR VGND sky130_ef_sc_hd__decap_12
XFILLER_55_271 VGND VGND VPWR VPWR sky130_fd_sc_hd__fill_1
XFILLER_47_249 VPWR VGND VPWR VGND sky130_ef_sc_hd__decap_12
XFILLER_46_54 VGND VGND VPWR VPWR sky130_fd_sc_hd__fill_1
XFILLER_15_113 VPWR VGND VPWR VGND sky130_ef_sc_hd__decap_12
XFILLER_62_97 VPWR VGND VPWR VGND sky130_ef_sc_hd__decap_12
XFILLER_62_53 VPWR VGND VPWR VGND sky130_ef_sc_hd__decap_12
XFILLER_30_149 VGND VGND VPWR VPWR sky130_fd_sc_hd__decap_6
XFILLER_7_15 VPWR VGND VPWR VGND sky130_ef_sc_hd__decap_12
XFILLER_11_385 VGND VGND VPWR VPWR sky130_fd_sc_hd__decap_6
XFILLER_30_7 VPWR VGND VPWR VGND sky130_ef_sc_hd__decap_12
X_1032_ _0345_ _0363_ _0362_ VGND VGND VPWR VPWR _0364_ sky130_fd_sc_hd__and3_1
X_1101_ net74 net81 _0353_ VGND VGND VPWR VPWR _0431_ sky130_fd_sc_hd__a21oi_2
XFILLER_46_271 VPWR VGND VPWR VGND sky130_ef_sc_hd__decap_12
XTAP_TAPCELL_ROW_44_450 VGND VPWR sky130_fd_sc_hd__tapvpwrvgnd_1
X_0747_ net148 net105 _0118_ net59 net112 VGND VGND VPWR VPWR _0016_ sky130_fd_sc_hd__o221a_1
X_0816_ net109 _0153_ _0155_ VGND VGND VPWR VPWR _0049_ sky130_fd_sc_hd__and3_1
XFILLER_29_205 VGND VGND VPWR VPWR sky130_fd_sc_hd__fill_1
XFILLER_37_293 VPWR VGND VPWR VGND sky130_ef_sc_hd__decap_12
XFILLER_29_238 VGND VGND VPWR VPWR sky130_fd_sc_hd__fill_2
XFILLER_52_263 VGND VGND VPWR VPWR sky130_fd_sc_hd__fill_2
XFILLER_12_149 VPWR VGND VPWR VGND sky130_ef_sc_hd__decap_12
XFILLER_57_42 VPWR VGND VPWR VGND sky130_ef_sc_hd__decap_12
XTAP_TAPCELL_ROW_7_186 VGND VPWR sky130_fd_sc_hd__tapvpwrvgnd_1
XFILLER_28_282 VPWR VGND VPWR VGND sky130_ef_sc_hd__decap_12
XFILLER_21_3 VGND VGND VPWR VPWR sky130_fd_sc_hd__decap_6
X_1015_ net70 net72 net84 net86 VGND VGND VPWR VPWR _0347_ sky130_fd_sc_hd__and4_1
XTAP_TAPCELL_ROW_64_589 VGND VPWR sky130_fd_sc_hd__tapvpwrvgnd_1
XFILLER_1_329 VGND VGND VPWR VPWR sky130_fd_sc_hd__decap_6
XFILLER_57_333 VGND VGND VPWR VPWR sky130_fd_sc_hd__decap_3
XTAP_TAPCELL_ROW_4_167 VGND VPWR sky130_fd_sc_hd__tapvpwrvgnd_1
XTAP_TAPCELL_ROW_55_523 VGND VPWR sky130_fd_sc_hd__tapvpwrvgnd_1
XFILLER_43_55 VGND VGND VPWR VPWR sky130_fd_sc_hd__fill_1
XFILLER_25_263 VPWR VGND VPWR VGND sky130_ef_sc_hd__decap_12
XFILLER_40_299 VGND VGND VPWR VPWR sky130_fd_sc_hd__decap_8
XFILLER_4_189 VGND VGND VPWR VPWR sky130_fd_sc_hd__decap_6
XFILLER_4_27 VGND VGND VPWR VPWR sky130_fd_sc_hd__fill_1
XFILLER_48_377 VGND VGND VPWR VPWR sky130_fd_sc_hd__decap_4
XFILLER_31_222 VGND VGND VPWR VPWR sky130_fd_sc_hd__fill_2
XTAP_TAPCELL_ROW_18_269 VGND VPWR sky130_fd_sc_hd__tapvpwrvgnd_1
XFILLER_58_108 VPWR VGND VPWR VGND sky130_ef_sc_hd__decap_12
XTAP_TAPCELL_ROW_52_504 VGND VPWR sky130_fd_sc_hd__tapvpwrvgnd_1
XTAP_TAPCELL_ROW_1_148 VGND VPWR sky130_fd_sc_hd__tapvpwrvgnd_1
Xfanout59 _0119_ VGND VGND VPWR VPWR net59 sky130_fd_sc_hd__clkbuf_4
XFILLER_22_244 VGND VGND VPWR VPWR sky130_fd_sc_hd__decap_8
XFILLER_22_277 VGND VGND VPWR VPWR sky130_fd_sc_hd__decap_6
XFILLER_49_108 VGND VGND VPWR VPWR sky130_fd_sc_hd__decap_4
XFILLER_1_137 VPWR VGND VPWR VGND sky130_ef_sc_hd__decap_12
XTAP_TAPCELL_ROW_9_204 VGND VPWR sky130_fd_sc_hd__tapvpwrvgnd_1
XFILLER_54_65 VPWR VGND VPWR VGND sky130_ef_sc_hd__decap_12
XFILLER_13_255 VPWR VGND VPWR VGND sky130_ef_sc_hd__decap_12
XFILLER_48_141 VPWR VGND VPWR VGND sky130_ef_sc_hd__decap_12
X_1280_ net99 core_out\[16\] net113 _0603_ VGND VGND VPWR VPWR _0065_ sky130_fd_sc_hd__o211a_1
XFILLER_0_181 VPWR VGND VPWR VGND sky130_ef_sc_hd__decap_12
XFILLER_63_111 VGND VGND VPWR VPWR sky130_fd_sc_hd__fill_1
XFILLER_51_328 VGND VGND VPWR VPWR sky130_fd_sc_hd__decap_8
XFILLER_51_306 VGND VGND VPWR VPWR sky130_fd_sc_hd__decap_4
X_0995_ _0292_ _0326_ _0327_ VGND VGND VPWR VPWR _0328_ sky130_fd_sc_hd__nand3_1
XFILLER_5_81 VPWR VGND VPWR VGND sky130_ef_sc_hd__decap_12
XFILLER_54_133 VGND VGND VPWR VPWR sky130_fd_sc_hd__decap_6
XFILLER_42_317 VGND VGND VPWR VPWR sky130_fd_sc_hd__decap_4
XTAP_TAPCELL_ROW_37_397 VGND VPWR sky130_fd_sc_hd__tapvpwrvgnd_1
XFILLER_40_89 VPWR VGND VPWR VGND sky130_ef_sc_hd__decap_12
XFILLER_49_32 VGND VGND VPWR VPWR sky130_fd_sc_hd__decap_3
XFILLER_45_177 VGND VGND VPWR VPWR sky130_fd_sc_hd__fill_2
XFILLER_45_111 VGND VGND VPWR VPWR sky130_fd_sc_hd__fill_1
XFILLER_33_317 VPWR VGND VPWR VGND sky130_ef_sc_hd__decap_12
XFILLER_26_380 VGND VGND VPWR VPWR sky130_fd_sc_hd__decap_3
XFILLER_1_39 VPWR VGND VPWR VGND sky130_ef_sc_hd__decap_12
X_0780_ core_out\[24\] _0103_ VGND VGND VPWR VPWR _0136_ sky130_fd_sc_hd__and2_1
XFILLER_41_372 VGND VGND VPWR VPWR sky130_fd_sc_hd__decap_3
XTAP_TAPCELL_ROW_11_220 VGND VPWR sky130_fd_sc_hd__tapvpwrvgnd_1
X_1401_ clknet_3_6__leaf_clk _0017_ VGND VGND VPWR VPWR net50 sky130_fd_sc_hd__dfxtp_1
XFILLER_5_273 VGND VGND VPWR VPWR sky130_fd_sc_hd__decap_6
Xinput5 addr[4] VGND VGND VPWR VPWR net5 sky130_fd_sc_hd__clkbuf_1
X_1332_ _0646_ _0647_ net101 VGND VGND VPWR VPWR _0648_ sky130_fd_sc_hd__a21bo_1
X_1194_ _0451_ _0488_ _0487_ VGND VGND VPWR VPWR _0522_ sky130_fd_sc_hd__a21o_1
X_1263_ _0533_ _0537_ _0564_ _0587_ VGND VGND VPWR VPWR _0588_ sky130_fd_sc_hd__a211o_1
XFILLER_36_166 VGND VGND VPWR VPWR sky130_fd_sc_hd__decap_8
XTAP_TAPCELL_ROW_34_378 VGND VPWR sky130_fd_sc_hd__tapvpwrvgnd_1
XFILLER_17_391 VGND VGND VPWR VPWR sky130_fd_sc_hd__fill_1
X_0978_ _0309_ _0308_ net124 _0266_ VGND VGND VPWR VPWR _0311_ sky130_fd_sc_hd__a211o_1
XFILLER_10_15 VPWR VGND VPWR VGND sky130_ef_sc_hd__decap_12
XFILLER_59_214 VGND VGND VPWR VPWR sky130_fd_sc_hd__decap_8
XFILLER_42_114 VGND VGND VPWR VPWR sky130_fd_sc_hd__decap_8
XFILLER_27_199 VGND VGND VPWR VPWR sky130_fd_sc_hd__decap_8
XFILLER_27_177 VGND VGND VPWR VPWR sky130_fd_sc_hd__decap_3
XFILLER_15_317 VPWR VGND VPWR VGND sky130_ef_sc_hd__decap_12
XFILLER_19_57 VGND VGND VPWR VPWR sky130_fd_sc_hd__decap_8
XTAP_TAPCELL_ROW_25_312 VGND VPWR sky130_fd_sc_hd__tapvpwrvgnd_1
XFILLER_51_77 VPWR VGND VPWR VGND sky130_ef_sc_hd__decap_12
XFILLER_51_55 VGND VGND VPWR VPWR sky130_fd_sc_hd__fill_1
XFILLER_51_33 VGND VGND VPWR VPWR sky130_fd_sc_hd__decap_8
XFILLER_30_309 VGND VGND VPWR VPWR sky130_fd_sc_hd__decap_8
XFILLER_23_361 VPWR VGND VPWR VGND sky130_ef_sc_hd__decap_12
XFILLER_2_265 VPWR VGND VPWR VGND sky130_ef_sc_hd__decap_12
XFILLER_2_221 VPWR VGND VPWR VGND sky130_ef_sc_hd__decap_12
XFILLER_18_122 VPWR VGND VPWR VGND sky130_ef_sc_hd__decap_12
XFILLER_33_169 VPWR VGND VPWR VGND sky130_ef_sc_hd__decap_12
XFILLER_18_166 VPWR VGND VPWR VGND sky130_ef_sc_hd__decap_12
X_0901_ _0233_ _0234_ _0226_ VGND VGND VPWR VPWR _0236_ sky130_fd_sc_hd__a21o_1
X_0832_ _0167_ _0168_ _0157_ VGND VGND VPWR VPWR _0170_ sky130_fd_sc_hd__a21oi_1
X_0763_ net154 net106 net57 _0127_ net113 VGND VGND VPWR VPWR _0024_ sky130_fd_sc_hd__o221a_1
XTAP_TAPCELL_ROW_31_359 VGND VPWR sky130_fd_sc_hd__tapvpwrvgnd_1
X_0694_ net9 VGND VGND VPWR VPWR _0083_ sky130_fd_sc_hd__inv_2
X_1315_ _0631_ _0632_ VGND VGND VPWR VPWR _0633_ sky130_fd_sc_hd__nand2_1
XFILLER_64_250 VGND VGND VPWR VPWR sky130_fd_sc_hd__fill_2
XFILLER_56_239 VGND VGND VPWR VPWR sky130_fd_sc_hd__decap_4
XFILLER_56_217 VGND VGND VPWR VPWR sky130_fd_sc_hd__decap_3
XTAP_TAPCELL_ROW_47_470 VGND VPWR sky130_fd_sc_hd__tapvpwrvgnd_1
XTAP_TAPCELL_ROW_39_415 VGND VPWR sky130_fd_sc_hd__tapvpwrvgnd_1
X_1177_ net68 net82 _0473_ _0434_ VGND VGND VPWR VPWR _0505_ sky130_fd_sc_hd__a31o_1
X_1246_ _0570_ _0571_ VGND VGND VPWR VPWR _0572_ sky130_fd_sc_hd__xor2_1
XFILLER_12_309 VPWR VGND VPWR VGND sky130_ef_sc_hd__decap_12
XFILLER_21_14 VGND VGND VPWR VPWR sky130_fd_sc_hd__decap_3
XFILLER_55_261 VGND VGND VPWR VPWR sky130_fd_sc_hd__decap_3
XFILLER_30_106 VGND VGND VPWR VPWR sky130_fd_sc_hd__decap_6
XFILLER_15_125 VGND VGND VPWR VPWR sky130_fd_sc_hd__decap_6
XFILLER_62_65 VPWR VGND VPWR VGND sky130_ef_sc_hd__decap_12
XFILLER_30_139 VGND VGND VPWR VPWR sky130_fd_sc_hd__fill_1
XFILLER_7_27 VPWR VGND VPWR VGND sky130_ef_sc_hd__decap_12
XFILLER_7_335 VGND VGND VPWR VPWR sky130_fd_sc_hd__fill_1
XFILLER_11_91 VGND VGND VPWR VPWR sky130_fd_sc_hd__fill_2
XFILLER_46_283 VGND VGND VPWR VPWR sky130_fd_sc_hd__fill_2
X_1031_ _0360_ _0359_ _0361_ VGND VGND VPWR VPWR _0363_ sky130_fd_sc_hd__a21o_1
X_1100_ _0385_ _0429_ VGND VGND VPWR VPWR _0430_ sky130_fd_sc_hd__xnor2_1
XFILLER_61_275 VGND VGND VPWR VPWR sky130_fd_sc_hd__decap_4
XTAP_TAPCELL_ROW_44_451 VGND VPWR sky130_fd_sc_hd__tapvpwrvgnd_1
X_0815_ net97 _0154_ VGND VGND VPWR VPWR _0155_ sky130_fd_sc_hd__nand2_1
X_0746_ net81 net63 _0100_ net65 _0102_ VGND VGND VPWR VPWR _0119_ sky130_fd_sc_hd__a221o_1
XFILLER_52_253 VGND VGND VPWR VPWR sky130_fd_sc_hd__decap_6
XFILLER_52_231 VGND VGND VPWR VPWR sky130_fd_sc_hd__decap_6
XFILLER_40_404 VGND VGND VPWR VPWR sky130_fd_sc_hd__decap_3
XFILLER_37_250 VPWR VGND VPWR VGND sky130_ef_sc_hd__decap_12
X_1229_ _0497_ _0528_ _0527_ VGND VGND VPWR VPWR _0556_ sky130_fd_sc_hd__o21bai_1
XFILLER_25_401 VGND VGND VPWR VPWR sky130_fd_sc_hd__fill_2
XTAP_TAPCELL_ROW_50_487 VGND VPWR sky130_fd_sc_hd__tapvpwrvgnd_1
XTAP_TAPCELL_ROW_58_543 VGND VPWR sky130_fd_sc_hd__tapvpwrvgnd_1
XFILLER_57_54 VGND VGND VPWR VPWR sky130_fd_sc_hd__fill_2
XTAP_TAPCELL_ROW_7_187 VGND VPWR sky130_fd_sc_hd__tapvpwrvgnd_1
XFILLER_16_401 VGND VGND VPWR VPWR sky130_fd_sc_hd__decap_6
XFILLER_31_404 VGND VGND VPWR VPWR sky130_fd_sc_hd__decap_3
XFILLER_28_294 VPWR VGND VPWR VGND sky130_ef_sc_hd__decap_12
XFILLER_3_393 VPWR VGND VPWR VGND sky130_ef_sc_hd__decap_12
XFILLER_14_3 VPWR VGND VPWR VGND sky130_ef_sc_hd__decap_12
XFILLER_34_253 VPWR VGND VPWR VGND sky130_ef_sc_hd__decap_12
XFILLER_26_209 VPWR VGND VPWR VGND sky130_ef_sc_hd__decap_12
XPHY_EDGE_ROW_14_Left_79 VGND VGND VPWR VPWR sky130_fd_sc_hd__decap_3
X_1014_ net68 net88 VGND VGND VPWR VPWR _0346_ sky130_fd_sc_hd__nand2_1
X_0729_ net136 net107 _0107_ net109 VGND VGND VPWR VPWR _0010_ sky130_fd_sc_hd__o211a_1
XTAP_TAPCELL_ROW_55_524 VGND VPWR sky130_fd_sc_hd__tapvpwrvgnd_1
XTAP_TAPCELL_ROW_4_168 VGND VPWR sky130_fd_sc_hd__tapvpwrvgnd_1
XFILLER_40_234 VGND VGND VPWR VPWR sky130_fd_sc_hd__decap_4
XFILLER_25_275 VGND VGND VPWR VPWR sky130_fd_sc_hd__decap_4
XFILLER_48_301 VGND VGND VPWR VPWR sky130_fd_sc_hd__decap_6
XFILLER_63_337 VPWR VGND VPWR VGND sky130_ef_sc_hd__decap_12
XFILLER_16_242 VGND VGND VPWR VPWR sky130_fd_sc_hd__decap_4
XFILLER_31_289 VGND VGND VPWR VPWR sky130_fd_sc_hd__fill_1
XFILLER_39_345 VPWR VGND VPWR VGND sky130_ef_sc_hd__decap_12
XTAP_TAPCELL_ROW_1_149 VGND VPWR sky130_fd_sc_hd__tapvpwrvgnd_1
XTAP_TAPCELL_ROW_52_505 VGND VPWR sky130_fd_sc_hd__tapvpwrvgnd_1
XFILLER_13_15 VPWR VGND VPWR VGND sky130_ef_sc_hd__decap_12
XTAP_TAPCELL_ROW_60_560 VGND VPWR sky130_fd_sc_hd__tapvpwrvgnd_1
XTAP_TAPCELL_ROW_9_205 VGND VPWR sky130_fd_sc_hd__tapvpwrvgnd_1
XFILLER_1_105 VGND VGND VPWR VPWR sky130_fd_sc_hd__decap_6
XFILLER_1_149 VPWR VGND VPWR VGND sky130_ef_sc_hd__decap_12
XFILLER_45_337 VPWR VGND VPWR VGND sky130_ef_sc_hd__decap_12
XFILLER_38_67 VPWR VGND VPWR VGND sky130_ef_sc_hd__decap_12
XFILLER_54_77 VGND VGND VPWR VPWR sky130_fd_sc_hd__decap_6
XFILLER_13_223 VGND VGND VPWR VPWR sky130_fd_sc_hd__fill_1
XFILLER_13_267 VPWR VGND VPWR VGND sky130_ef_sc_hd__decap_12
XFILLER_48_153 VGND VGND VPWR VPWR sky130_fd_sc_hd__decap_4
XFILLER_48_131 VGND VGND VPWR VPWR sky130_fd_sc_hd__fill_2
XFILLER_0_193 VGND VGND VPWR VPWR sky130_fd_sc_hd__decap_3
XFILLER_63_189 VPWR VGND VPWR VGND sky130_ef_sc_hd__decap_12
XFILLER_63_167 VGND VGND VPWR VPWR sky130_fd_sc_hd__fill_1
XFILLER_48_197 VGND VGND VPWR VPWR sky130_fd_sc_hd__decap_4
XFILLER_44_370 VPWR VGND VPWR VGND sky130_ef_sc_hd__decap_12
X_0994_ _0324_ _0325_ _0280_ VGND VGND VPWR VPWR _0327_ sky130_fd_sc_hd__a21o_1
XTAP_TAPCELL_ROW_14_240 VGND VPWR sky130_fd_sc_hd__tapvpwrvgnd_1
XFILLER_5_93 VPWR VGND VPWR VGND sky130_ef_sc_hd__decap_12
XFILLER_54_167 VPWR VGND VPWR VGND sky130_ef_sc_hd__decap_12
XFILLER_39_153 VPWR VGND VPWR VGND sky130_ef_sc_hd__decap_12
XFILLER_27_337 VGND VGND VPWR VPWR sky130_fd_sc_hd__decap_3
XFILLER_50_351 VPWR VGND VPWR VGND sky130_ef_sc_hd__decap_12
XTAP_TAPCELL_ROW_37_398 VGND VPWR sky130_fd_sc_hd__tapvpwrvgnd_1
XPHY_EDGE_ROW_17_Left_82 VGND VGND VPWR VPWR sky130_fd_sc_hd__decap_3
XFILLER_24_25 VGND VGND VPWR VPWR sky130_fd_sc_hd__decap_3
XFILLER_40_24 VGND VGND VPWR VPWR sky130_fd_sc_hd__decap_4
XFILLER_6_219 VGND VGND VPWR VPWR sky130_fd_sc_hd__fill_1
XFILLER_49_55 VGND VGND VPWR VPWR sky130_fd_sc_hd__fill_1
XFILLER_26_370 VGND VGND VPWR VPWR sky130_fd_sc_hd__fill_1
X_1400_ clknet_3_6__leaf_clk _0016_ VGND VGND VPWR VPWR net49 sky130_fd_sc_hd__dfxtp_1
X_1331_ _0642_ _0643_ _0645_ VGND VGND VPWR VPWR _0647_ sky130_fd_sc_hd__nand3_1
Xinput6 addr[5] VGND VGND VPWR VPWR net6 sky130_fd_sc_hd__clkbuf_1
X_1262_ _0531_ _0532_ _0563_ VGND VGND VPWR VPWR _0587_ sky130_fd_sc_hd__mux2_1
X_1193_ _0520_ VGND VGND VPWR VPWR _0521_ sky130_fd_sc_hd__inv_2
XTAP_TAPCELL_ROW_34_379 VGND VPWR sky130_fd_sc_hd__tapvpwrvgnd_1
XFILLER_32_373 VPWR VGND VPWR VGND sky130_ef_sc_hd__decap_12
X_0977_ net124 _0266_ _0308_ _0309_ VGND VGND VPWR VPWR _0310_ sky130_fd_sc_hd__o211ai_2
XFILLER_10_27 VGND VGND VPWR VPWR sky130_fd_sc_hd__fill_1
XFILLER_59_204 VGND VGND VPWR VPWR sky130_fd_sc_hd__decap_4
XFILLER_35_57 VPWR VGND VPWR VGND sky130_ef_sc_hd__decap_12
XFILLER_27_123 VPWR VGND VPWR VGND sky130_ef_sc_hd__decap_12
XFILLER_15_329 VGND VGND VPWR VPWR sky130_fd_sc_hd__decap_6
XTAP_TAPCELL_ROW_25_313 VGND VPWR sky130_fd_sc_hd__tapvpwrvgnd_1
XFILLER_51_89 VPWR VGND VPWR VGND sky130_ef_sc_hd__decap_12
Xclkbuf_3_3__f_clk clknet_0_clk VGND VGND VPWR VPWR clknet_3_3__leaf_clk sky130_fd_sc_hd__clkbuf_16
XPHY_EDGE_ROW_2_Left_67 VGND VGND VPWR VPWR sky130_fd_sc_hd__decap_3
XPHY_EDGE_ROW_14_Right_14 VGND VGND VPWR VPWR sky130_fd_sc_hd__decap_3
XFILLER_23_373 VPWR VGND VPWR VGND sky130_ef_sc_hd__decap_12
XFILLER_2_277 VPWR VGND VPWR VGND sky130_ef_sc_hd__decap_12
XFILLER_2_233 VPWR VGND VPWR VGND sky130_ef_sc_hd__decap_12
XPHY_EDGE_ROW_23_Right_23 VGND VGND VPWR VPWR sky130_fd_sc_hd__decap_3
XFILLER_58_281 VGND VGND VPWR VPWR sky130_fd_sc_hd__decap_4
XFILLER_18_134 VGND VGND VPWR VPWR sky130_fd_sc_hd__decap_6
X_0900_ _0226_ _0233_ _0234_ VGND VGND VPWR VPWR _0235_ sky130_fd_sc_hd__nand3_1
XFILLER_33_104 VGND VGND VPWR VPWR sky130_fd_sc_hd__decap_8
XPHY_EDGE_ROW_32_Right_32 VGND VGND VPWR VPWR sky130_fd_sc_hd__decap_3
XFILLER_18_178 VPWR VGND VPWR VGND sky130_ef_sc_hd__decap_12
XFILLER_25_90 VGND VGND VPWR VPWR sky130_fd_sc_hd__decap_3
X_0693_ net4 VGND VGND VPWR VPWR _0082_ sky130_fd_sc_hd__inv_2
X_0831_ _0157_ _0167_ _0168_ VGND VGND VPWR VPWR _0169_ sky130_fd_sc_hd__and3_1
X_0762_ core_out\[15\] net61 VGND VGND VPWR VPWR _0127_ sky130_fd_sc_hd__and2_1
X_1314_ core_out\[22\] net54 VGND VGND VPWR VPWR _0632_ sky130_fd_sc_hd__nand2_1
XPHY_EDGE_ROW_41_Right_41 VGND VGND VPWR VPWR sky130_fd_sc_hd__decap_3
XTAP_TAPCELL_ROW_39_416 VGND VPWR sky130_fd_sc_hd__tapvpwrvgnd_1
XPHY_EDGE_ROW_50_Right_50 VGND VGND VPWR VPWR sky130_fd_sc_hd__decap_3
XFILLER_49_270 VGND VGND VPWR VPWR sky130_fd_sc_hd__decap_6
XTAP_TAPCELL_ROW_47_471 VGND VPWR sky130_fd_sc_hd__tapvpwrvgnd_1
XFILLER_2_83 VGND VGND VPWR VPWR sky130_fd_sc_hd__fill_1
X_1245_ _0546_ _0547_ _0544_ VGND VGND VPWR VPWR _0571_ sky130_fd_sc_hd__o21a_1
X_1176_ _0501_ _0502_ VGND VGND VPWR VPWR _0504_ sky130_fd_sc_hd__xnor2_1
XFILLER_20_321 VPWR VGND VPWR VGND sky130_ef_sc_hd__decap_12
XFILLER_20_365 VPWR VGND VPWR VGND sky130_ef_sc_hd__decap_12
XFILLER_21_26 VGND VGND VPWR VPWR sky130_fd_sc_hd__decap_8
XFILLER_62_77 VGND VGND VPWR VPWR sky130_fd_sc_hd__decap_6
XFILLER_30_118 VGND VGND VPWR VPWR sky130_fd_sc_hd__decap_8
XFILLER_7_39 VPWR VGND VPWR VGND sky130_ef_sc_hd__decap_12
XFILLER_61_243 VGND VGND VPWR VPWR sky130_fd_sc_hd__fill_1
X_1030_ _0359_ _0360_ _0361_ VGND VGND VPWR VPWR _0362_ sky130_fd_sc_hd__nand3_2
XFILLER_61_265 VGND VGND VPWR VPWR sky130_fd_sc_hd__fill_1
X_0814_ core_out\[0\] net78 net94 VGND VGND VPWR VPWR _0154_ sky130_fd_sc_hd__and3_1
XFILLER_14_181 VPWR VGND VPWR VGND sky130_ef_sc_hd__decap_12
X_0745_ core_out\[7\] net60 VGND VGND VPWR VPWR _0118_ sky130_fd_sc_hd__and2_1
X_1228_ core_out\[13\] _0554_ VGND VGND VPWR VPWR _0555_ sky130_fd_sc_hd__xor2_1
XFILLER_52_287 VGND VGND VPWR VPWR sky130_fd_sc_hd__fill_1
XFILLER_37_262 VGND VGND VPWR VPWR sky130_fd_sc_hd__fill_2
X_1159_ _0447_ _0449_ _0486_ VGND VGND VPWR VPWR _0488_ sky130_fd_sc_hd__nand3_1
XFILLER_16_15 VPWR VGND VPWR VGND sky130_ef_sc_hd__decap_12
XTAP_TAPCELL_ROW_50_488 VGND VPWR sky130_fd_sc_hd__tapvpwrvgnd_1
XFILLER_20_173 VGND VGND VPWR VPWR sky130_fd_sc_hd__decap_3
XFILLER_20_195 VGND VGND VPWR VPWR sky130_fd_sc_hd__fill_1
XTAP_TAPCELL_ROW_7_188 VGND VPWR sky130_fd_sc_hd__tapvpwrvgnd_1
XTAP_TAPCELL_ROW_58_544 VGND VPWR sky130_fd_sc_hd__tapvpwrvgnd_1
XFILLER_43_210 VPWR VGND VPWR VGND sky130_ef_sc_hd__decap_12
XFILLER_7_111 VGND VGND VPWR VPWR sky130_fd_sc_hd__fill_1
XPHY_EDGE_ROW_5_Left_70 VGND VGND VPWR VPWR sky130_fd_sc_hd__decap_3
XFILLER_3_361 VPWR VGND VPWR VGND sky130_ef_sc_hd__decap_12
XFILLER_34_265 VPWR VGND VPWR VGND sky130_ef_sc_hd__decap_12
XFILLER_34_221 VPWR VGND VPWR VGND sky130_ef_sc_hd__decap_12
X_1013_ _0337_ _0343_ VGND VGND VPWR VPWR _0345_ sky130_fd_sc_hd__xnor2_1
XFILLER_19_251 VPWR VGND VPWR VGND sky130_ef_sc_hd__decap_12
X_0728_ core_out\[1\] net62 _0106_ _0102_ VGND VGND VPWR VPWR _0107_ sky130_fd_sc_hd__a211o_1
XPHY_EDGE_ROW_4_Right_4 VGND VGND VPWR VPWR sky130_fd_sc_hd__decap_3
XFILLER_57_313 VPWR VGND VPWR VGND sky130_ef_sc_hd__decap_12
XTAP_TAPCELL_ROW_55_525 VGND VPWR sky130_fd_sc_hd__tapvpwrvgnd_1
XTAP_TAPCELL_ROW_4_169 VGND VPWR sky130_fd_sc_hd__tapvpwrvgnd_1
XTAP_TAPCELL_ROW_63_580 VGND VPWR sky130_fd_sc_hd__tapvpwrvgnd_1
XFILLER_43_57 VPWR VGND VPWR VGND sky130_ef_sc_hd__decap_12
XFILLER_13_405 VGND VGND VPWR VPWR sky130_fd_sc_hd__fill_2
XFILLER_4_29 VPWR VGND VPWR VGND sky130_ef_sc_hd__decap_12
XPHY_EDGE_ROW_31_Left_96 VGND VGND VPWR VPWR sky130_fd_sc_hd__decap_3
XFILLER_63_349 VPWR VGND VPWR VGND sky130_ef_sc_hd__decap_12
XFILLER_63_305 VPWR VGND VPWR VGND sky130_ef_sc_hd__decap_12
XFILLER_16_221 VGND VGND VPWR VPWR sky130_fd_sc_hd__fill_1
XFILLER_16_232 VGND VGND VPWR VPWR sky130_fd_sc_hd__decap_4
XFILLER_39_357 VGND VGND VPWR VPWR sky130_fd_sc_hd__decap_4
XFILLER_39_335 VGND VGND VPWR VPWR sky130_fd_sc_hd__fill_1
XFILLER_39_302 VGND VGND VPWR VPWR sky130_fd_sc_hd__decap_4
XTAP_TAPCELL_ROW_60_561 VGND VPWR sky130_fd_sc_hd__tapvpwrvgnd_1
XTAP_TAPCELL_ROW_52_506 VGND VPWR sky130_fd_sc_hd__tapvpwrvgnd_1
XFILLER_13_27 VPWR VGND VPWR VGND sky130_ef_sc_hd__decap_12
XTAP_TAPCELL_ROW_17_260 VGND VPWR sky130_fd_sc_hd__tapvpwrvgnd_1
XFILLER_22_213 VPWR VGND VPWR VGND sky130_ef_sc_hd__decap_12
XTAP_TAPCELL_ROW_9_206 VGND VPWR sky130_fd_sc_hd__tapvpwrvgnd_1
XFILLER_38_79 VGND VGND VPWR VPWR sky130_fd_sc_hd__decap_4
XFILLER_53_393 VGND VGND VPWR VPWR sky130_fd_sc_hd__fill_2
XFILLER_45_316 VPWR VGND VPWR VGND sky130_ef_sc_hd__decap_12
XFILLER_45_305 VGND VGND VPWR VPWR sky130_fd_sc_hd__fill_2
XFILLER_9_217 VGND VGND VPWR VPWR sky130_fd_sc_hd__decap_6
XFILLER_13_279 VGND VGND VPWR VPWR sky130_fd_sc_hd__fill_1
XFILLER_63_113 VPWR VGND VPWR VGND sky130_ef_sc_hd__decap_12
X_0993_ _0280_ _0324_ _0325_ VGND VGND VPWR VPWR _0326_ sky130_fd_sc_hd__nand3_1
XTAP_TAPCELL_ROW_14_241 VGND VPWR sky130_fd_sc_hd__tapvpwrvgnd_1
XFILLER_54_179 VGND VGND VPWR VPWR sky130_fd_sc_hd__fill_1
XFILLER_39_165 VGND VGND VPWR VPWR sky130_fd_sc_hd__decap_3
XTAP_TAPCELL_ROW_37_399 VGND VPWR sky130_fd_sc_hd__tapvpwrvgnd_1
XFILLER_27_327 VGND VGND VPWR VPWR sky130_fd_sc_hd__decap_8
XFILLER_24_15 VGND VGND VPWR VPWR sky130_fd_sc_hd__fill_1
XFILLER_50_363 VGND VGND VPWR VPWR sky130_fd_sc_hd__fill_1
XFILLER_35_393 VGND VGND VPWR VPWR sky130_fd_sc_hd__fill_1
XTAP_TAPCELL_ROW_20_277 VGND VPWR sky130_fd_sc_hd__tapvpwrvgnd_1
XFILLER_41_330 VGND VGND VPWR VPWR sky130_fd_sc_hd__decap_6
XTAP_TAPCELL_ROW_28_333 VGND VPWR sky130_fd_sc_hd__tapvpwrvgnd_1
XFILLER_14_81 VGND VGND VPWR VPWR sky130_fd_sc_hd__decap_3
X_1330_ _0643_ _0645_ _0642_ VGND VGND VPWR VPWR _0646_ sky130_fd_sc_hd__a21o_1
XFILLER_46_7 VGND VGND VPWR VPWR sky130_fd_sc_hd__fill_2
X_1261_ _0561_ _0568_ _0567_ VGND VGND VPWR VPWR _0586_ sky130_fd_sc_hd__a21oi_1
Xinput7 addr[6] VGND VGND VPWR VPWR net7 sky130_fd_sc_hd__clkbuf_1
X_1192_ _0517_ _0518_ VGND VGND VPWR VPWR _0520_ sky130_fd_sc_hd__xor2_1
XFILLER_32_385 VGND VGND VPWR VPWR sky130_fd_sc_hd__decap_4
X_0976_ _0306_ _0307_ _0263_ VGND VGND VPWR VPWR _0309_ sky130_fd_sc_hd__o21ai_1
XFILLER_17_393 VPWR VGND VPWR VGND sky130_ef_sc_hd__decap_12
X_1459_ clknet_3_6__leaf_clk _0075_ VGND VGND VPWR VPWR core_out\[26\] sky130_fd_sc_hd__dfxtp_1
XFILLER_27_135 VGND VGND VPWR VPWR sky130_fd_sc_hd__decap_3
XFILLER_42_138 VGND VGND VPWR VPWR sky130_fd_sc_hd__fill_2
XFILLER_35_69 VGND VGND VPWR VPWR sky130_fd_sc_hd__decap_4
XTAP_TAPCELL_ROW_25_314 VGND VPWR sky130_fd_sc_hd__tapvpwrvgnd_1
XFILLER_51_57 VGND VGND VPWR VPWR sky130_fd_sc_hd__decap_8
XFILLER_50_182 VGND VGND VPWR VPWR sky130_fd_sc_hd__fill_2
XFILLER_23_385 VGND VGND VPWR VPWR sky130_fd_sc_hd__decap_6
XFILLER_4_3 VPWR VGND VPWR VGND sky130_ef_sc_hd__decap_12
XFILLER_2_289 VPWR VGND VPWR VGND sky130_ef_sc_hd__decap_12
XFILLER_2_245 VGND VGND VPWR VPWR sky130_fd_sc_hd__decap_6
X_0830_ _0165_ _0166_ _0164_ VGND VGND VPWR VPWR _0168_ sky130_fd_sc_hd__o21ai_1
XFILLER_14_363 VGND VGND VPWR VPWR sky130_fd_sc_hd__fill_1
X_0761_ net146 net106 net57 _0126_ net116 VGND VGND VPWR VPWR _0023_ sky130_fd_sc_hd__o221a_1
X_0692_ net65 VGND VGND VPWR VPWR _0081_ sky130_fd_sc_hd__inv_2
X_1313_ core_out\[22\] net53 VGND VGND VPWR VPWR _0631_ sky130_fd_sc_hd__or2_1
XFILLER_49_293 VGND VGND VPWR VPWR sky130_fd_sc_hd__decap_4
XFILLER_37_3 VGND VGND VPWR VPWR sky130_fd_sc_hd__decap_6
X_1244_ _0561_ _0569_ VGND VGND VPWR VPWR _0570_ sky130_fd_sc_hd__xnor2_1
XTAP_TAPCELL_ROW_47_472 VGND VPWR sky130_fd_sc_hd__tapvpwrvgnd_1
X_1175_ _0501_ _0502_ VGND VGND VPWR VPWR _0503_ sky130_fd_sc_hd__and2_1
XFILLER_24_149 VPWR VGND VPWR VGND sky130_ef_sc_hd__decap_12
X_0959_ _0245_ _0283_ _0282_ VGND VGND VPWR VPWR _0292_ sky130_fd_sc_hd__a21bo_1
XFILLER_32_193 VGND VGND VPWR VPWR sky130_fd_sc_hd__decap_3
XTAP_TAPCELL_ROW_30_350 VGND VPWR sky130_fd_sc_hd__tapvpwrvgnd_1
XFILLER_20_333 VPWR VGND VPWR VGND sky130_ef_sc_hd__decap_12
XFILLER_20_377 VPWR VGND VPWR VGND sky130_ef_sc_hd__decap_12
XFILLER_7_337 VPWR VGND VPWR VGND sky130_ef_sc_hd__decap_12
XFILLER_38_219 VPWR VGND VPWR VGND sky130_ef_sc_hd__decap_12
XFILLER_61_200 VGND VGND VPWR VPWR sky130_fd_sc_hd__fill_1
XFILLER_46_241 VGND VGND VPWR VPWR sky130_fd_sc_hd__decap_8
XFILLER_34_403 VGND VGND VPWR VPWR sky130_fd_sc_hd__decap_4
X_0813_ net97 net132 net94 core_out\[0\] VGND VGND VPWR VPWR _0153_ sky130_fd_sc_hd__a31o_1
Xinput10 valid VGND VGND VPWR VPWR net10 sky130_fd_sc_hd__clkbuf_2
XFILLER_14_193 VGND VGND VPWR VPWR sky130_fd_sc_hd__decap_3
X_0744_ net166 net107 _0117_ net110 VGND VGND VPWR VPWR _0015_ sky130_fd_sc_hd__o211a_1
X_1158_ _0447_ _0449_ _0486_ VGND VGND VPWR VPWR _0487_ sky130_fd_sc_hd__a21oi_1
X_1227_ _0551_ _0552_ VGND VGND VPWR VPWR _0554_ sky130_fd_sc_hd__xor2_2
X_1089_ _0418_ _0419_ _0382_ VGND VGND VPWR VPWR _0420_ sky130_fd_sc_hd__o21a_1
XFILLER_16_27 VGND VGND VPWR VPWR sky130_fd_sc_hd__fill_1
XFILLER_20_141 VPWR VGND VPWR VGND sky130_ef_sc_hd__decap_12
XTAP_TAPCELL_ROW_50_489 VGND VPWR sky130_fd_sc_hd__tapvpwrvgnd_1
XFILLER_4_307 VGND VGND VPWR VPWR sky130_fd_sc_hd__fill_1
XTAP_TAPCELL_ROW_7_189 VGND VPWR sky130_fd_sc_hd__tapvpwrvgnd_1
XTAP_TAPCELL_ROW_58_545 VGND VPWR sky130_fd_sc_hd__tapvpwrvgnd_1
XFILLER_43_222 VGND VGND VPWR VPWR sky130_fd_sc_hd__fill_2
XPHY_EDGE_ROW_44_Left_109 VGND VGND VPWR VPWR sky130_fd_sc_hd__decap_3
XFILLER_7_145 VGND VGND VPWR VPWR sky130_fd_sc_hd__fill_1
XFILLER_11_163 VGND VGND VPWR VPWR sky130_fd_sc_hd__fill_2
XFILLER_11_185 VPWR VGND VPWR VGND sky130_ef_sc_hd__decap_12
XFILLER_3_373 VPWR VGND VPWR VGND sky130_ef_sc_hd__decap_12
XPHY_EDGE_ROW_53_Left_118 VGND VGND VPWR VPWR sky130_fd_sc_hd__decap_3
X_1012_ _0337_ _0343_ VGND VGND VPWR VPWR _0344_ sky130_fd_sc_hd__nand2b_1
XFILLER_19_263 VPWR VGND VPWR VGND sky130_ef_sc_hd__decap_12
XFILLER_34_277 VPWR VGND VPWR VGND sky130_ef_sc_hd__decap_12
XFILLER_34_233 VGND VGND VPWR VPWR sky130_fd_sc_hd__decap_6
XPHY_EDGE_ROW_62_Left_127 VGND VGND VPWR VPWR sky130_fd_sc_hd__decap_3
X_0727_ net92 net64 _0100_ net76 VGND VGND VPWR VPWR _0106_ sky130_fd_sc_hd__a22o_1
XFILLER_57_325 VGND VGND VPWR VPWR sky130_fd_sc_hd__decap_8
XTAP_TAPCELL_ROW_55_526 VGND VPWR sky130_fd_sc_hd__tapvpwrvgnd_1
XFILLER_27_48 VGND VGND VPWR VPWR sky130_fd_sc_hd__fill_1
XFILLER_27_37 VGND VGND VPWR VPWR sky130_fd_sc_hd__decap_3
XTAP_TAPCELL_ROW_63_581 VGND VPWR sky130_fd_sc_hd__tapvpwrvgnd_1
XFILLER_43_69 VGND VGND VPWR VPWR sky130_fd_sc_hd__fill_1
XFILLER_0_321 VPWR VGND VPWR VGND sky130_ef_sc_hd__decap_12
XFILLER_63_317 VPWR VGND VPWR VGND sky130_ef_sc_hd__decap_12
XFILLER_0_365 VPWR VGND VPWR VGND sky130_ef_sc_hd__decap_12
XFILLER_31_225 VGND VGND VPWR VPWR sky130_fd_sc_hd__decap_6
XFILLER_31_214 VGND VGND VPWR VPWR sky130_fd_sc_hd__decap_8
XFILLER_16_288 VPWR VGND VPWR VGND sky130_ef_sc_hd__decap_12
XFILLER_3_181 VPWR VGND VPWR VGND sky130_ef_sc_hd__decap_12
XTAP_TAPCELL_ROW_52_507 VGND VPWR sky130_fd_sc_hd__tapvpwrvgnd_1
XFILLER_47_391 VGND VGND VPWR VPWR sky130_fd_sc_hd__fill_1
XFILLER_62_361 VGND VGND VPWR VPWR sky130_fd_sc_hd__decap_3
XTAP_TAPCELL_ROW_60_562 VGND VPWR sky130_fd_sc_hd__tapvpwrvgnd_1
XFILLER_13_39 VPWR VGND VPWR VGND sky130_ef_sc_hd__decap_12
XTAP_TAPCELL_ROW_17_261 VGND VPWR sky130_fd_sc_hd__tapvpwrvgnd_1
XFILLER_57_111 VGND VGND VPWR VPWR sky130_fd_sc_hd__fill_1
XFILLER_60_309 VPWR VGND VPWR VGND sky130_ef_sc_hd__decap_12
XFILLER_57_199 VGND VGND VPWR VPWR sky130_fd_sc_hd__fill_1
XFILLER_45_328 VGND VGND VPWR VPWR sky130_fd_sc_hd__decap_8
XTAP_TAPCELL_ROW_0_140 VGND VPWR sky130_fd_sc_hd__tapvpwrvgnd_1
XFILLER_63_169 VPWR VGND VPWR VGND sky130_ef_sc_hd__decap_12
XFILLER_63_125 VPWR VGND VPWR VGND sky130_ef_sc_hd__decap_12
XFILLER_29_380 VPWR VGND VPWR VGND sky130_ef_sc_hd__decap_12
X_0992_ _0320_ _0322_ _0253_ VGND VGND VPWR VPWR _0325_ sky130_fd_sc_hd__a21o_1
XFILLER_5_51 VGND VGND VPWR VPWR sky130_fd_sc_hd__decap_4
XFILLER_8_251 VGND VGND VPWR VPWR sky130_fd_sc_hd__fill_1
XFILLER_39_144 VGND VGND VPWR VPWR sky130_fd_sc_hd__fill_2
XFILLER_50_331 VPWR VGND VPWR VGND sky130_ef_sc_hd__decap_12
XFILLER_35_372 VGND VGND VPWR VPWR sky130_fd_sc_hd__fill_1
XTAP_TAPCELL_ROW_20_278 VGND VPWR sky130_fd_sc_hd__tapvpwrvgnd_1
XFILLER_49_24 VGND VGND VPWR VPWR sky130_fd_sc_hd__decap_8
XFILLER_45_169 VGND VGND VPWR VPWR sky130_fd_sc_hd__decap_8
XTAP_TAPCELL_ROW_28_334 VGND VPWR sky130_fd_sc_hd__tapvpwrvgnd_1
Xinput8 addr[7] VGND VGND VPWR VPWR net8 sky130_fd_sc_hd__clkbuf_1
XFILLER_39_7 VGND VGND VPWR VPWR sky130_fd_sc_hd__decap_6
X_1260_ net98 net169 net116 _0585_ VGND VGND VPWR VPWR _0063_ sky130_fd_sc_hd__o211a_1
X_1191_ _0517_ _0518_ VGND VGND VPWR VPWR _0519_ sky130_fd_sc_hd__and2b_1
XFILLER_17_361 VPWR VGND VPWR VGND sky130_ef_sc_hd__decap_12
XFILLER_24_309 VGND VGND VPWR VPWR sky130_fd_sc_hd__decap_4
X_0975_ _0263_ _0306_ _0307_ VGND VGND VPWR VPWR _0308_ sky130_fd_sc_hd__or3_4
XFILLER_10_29 VGND VGND VPWR VPWR sky130_fd_sc_hd__decap_4
X_1458_ clknet_3_7__leaf_clk _0074_ VGND VGND VPWR VPWR core_out\[25\] sky130_fd_sc_hd__dfxtp_1
XFILLER_35_15 VPWR VGND VPWR VGND sky130_ef_sc_hd__decap_12
X_1389_ clknet_3_1__leaf_clk _0005_ VGND VGND VPWR VPWR core_a\[4\] sky130_fd_sc_hd__dfxtp_1
XFILLER_51_14 VGND VGND VPWR VPWR sky130_fd_sc_hd__decap_3
XTAP_TAPCELL_ROW_33_370 VGND VPWR sky130_fd_sc_hd__tapvpwrvgnd_1
XFILLER_27_169 VGND VGND VPWR VPWR sky130_fd_sc_hd__decap_8
XTAP_TAPCELL_ROW_25_315 VGND VPWR sky130_fd_sc_hd__tapvpwrvgnd_1
XFILLER_33_128 VGND VGND VPWR VPWR sky130_fd_sc_hd__decap_3
XFILLER_33_117 VGND VGND VPWR VPWR sky130_fd_sc_hd__fill_1
X_0760_ core_out\[14\] net61 VGND VGND VPWR VPWR _0126_ sky130_fd_sc_hd__and2_1
XFILLER_51_6 VGND VGND VPWR VPWR sky130_fd_sc_hd__decap_8
XFILLER_64_231 VGND VGND VPWR VPWR sky130_fd_sc_hd__decap_3
XFILLER_56_209 VGND VGND VPWR VPWR sky130_fd_sc_hd__decap_8
X_1312_ net102 core_out\[21\] net114 _0630_ VGND VGND VPWR VPWR _0070_ sky130_fd_sc_hd__o211a_1
XFILLER_2_85 VPWR VGND VPWR VGND sky130_ef_sc_hd__decap_12
XFILLER_2_41 VPWR VGND VPWR VGND sky130_ef_sc_hd__decap_12
X_1243_ _0567_ _0568_ VGND VGND VPWR VPWR _0569_ sky130_fd_sc_hd__and2b_1
X_1174_ _0431_ _0476_ _0399_ VGND VGND VPWR VPWR _0502_ sky130_fd_sc_hd__o21ai_1
XFILLER_64_253 VGND VGND VPWR VPWR sky130_fd_sc_hd__decap_3
XFILLER_24_139 VGND VGND VPWR VPWR sky130_fd_sc_hd__fill_1
X_0958_ net96 net177 net111 _0291_ VGND VGND VPWR VPWR _0055_ sky130_fd_sc_hd__o211a_1
X_0889_ net69 net95 VGND VGND VPWR VPWR _0224_ sky130_fd_sc_hd__nand2_1
XTAP_TAPCELL_ROW_30_351 VGND VPWR sky130_fd_sc_hd__tapvpwrvgnd_1
XFILLER_20_345 VPWR VGND VPWR VGND sky130_ef_sc_hd__decap_12
XFILLER_20_389 VPWR VGND VPWR VGND sky130_ef_sc_hd__decap_12
XFILLER_55_220 VGND VGND VPWR VPWR sky130_fd_sc_hd__decap_4
XFILLER_7_305 VPWR VGND VPWR VGND sky130_ef_sc_hd__decap_12
XFILLER_7_349 VPWR VGND VPWR VGND sky130_ef_sc_hd__decap_12
XFILLER_46_253 VGND VGND VPWR VPWR sky130_fd_sc_hd__fill_1
X_0743_ core_out\[6\] net62 _0116_ _0102_ VGND VGND VPWR VPWR _0117_ sky130_fd_sc_hd__a211o_1
X_0812_ net108 _0152_ VGND VGND VPWR VPWR _0048_ sky130_fd_sc_hd__and2_1
Xinput11 wdata[0] VGND VGND VPWR VPWR net11 sky130_fd_sc_hd__buf_1
X_1157_ _0465_ _0485_ VGND VGND VPWR VPWR _0486_ sky130_fd_sc_hd__xnor2_1
X_1226_ _0520_ _0551_ VGND VGND VPWR VPWR _0553_ sky130_fd_sc_hd__and2b_1
X_1088_ core_out\[9\] _0416_ VGND VGND VPWR VPWR _0419_ sky130_fd_sc_hd__nor2_1
XFILLER_32_27 VGND VGND VPWR VPWR sky130_fd_sc_hd__fill_1
XFILLER_20_153 VPWR VGND VPWR VGND sky130_ef_sc_hd__decap_12
XFILLER_20_197 VGND VGND VPWR VPWR sky130_fd_sc_hd__decap_3
XTAP_TAPCELL_ROW_58_546 VGND VPWR sky130_fd_sc_hd__tapvpwrvgnd_1
XFILLER_57_57 VPWR VGND VPWR VGND sky130_ef_sc_hd__decap_12
XFILLER_43_289 VPWR VGND VPWR VGND sky130_ef_sc_hd__decap_12
XFILLER_43_201 VGND VGND VPWR VPWR sky130_fd_sc_hd__fill_1
XFILLER_28_253 VPWR VGND VPWR VGND sky130_ef_sc_hd__decap_12
XTAP_TAPCELL_ROW_41_424 VGND VPWR sky130_fd_sc_hd__tapvpwrvgnd_1
XFILLER_7_157 VGND VGND VPWR VPWR sky130_fd_sc_hd__decap_6
XFILLER_7_113 VPWR VGND VPWR VGND sky130_ef_sc_hd__decap_12
XFILLER_11_197 VGND VGND VPWR VPWR sky130_fd_sc_hd__decap_8
XFILLER_3_385 VGND VGND VPWR VPWR sky130_fd_sc_hd__decap_6
X_1011_ _0338_ _0341_ VGND VGND VPWR VPWR _0343_ sky130_fd_sc_hd__xnor2_1
XFILLER_19_275 VGND VGND VPWR VPWR sky130_fd_sc_hd__decap_4
XFILLER_34_289 VPWR VGND VPWR VGND sky130_ef_sc_hd__decap_12
X_0726_ net135 net107 _0105_ net109 VGND VGND VPWR VPWR _0009_ sky130_fd_sc_hd__o211a_1
XFILLER_57_337 VPWR VGND VPWR VGND sky130_ef_sc_hd__decap_12
XFILLER_57_304 VGND VGND VPWR VPWR sky130_fd_sc_hd__fill_2
XTAP_TAPCELL_ROW_63_582 VGND VPWR sky130_fd_sc_hd__tapvpwrvgnd_1
XTAP_TAPCELL_ROW_55_527 VGND VPWR sky130_fd_sc_hd__tapvpwrvgnd_1
XFILLER_40_226 VGND VGND VPWR VPWR sky130_fd_sc_hd__fill_1
X_1209_ net66 net80 net82 _0081_ VGND VGND VPWR VPWR _0536_ sky130_fd_sc_hd__o2bb2a_1
XFILLER_25_223 VGND VGND VPWR VPWR sky130_fd_sc_hd__fill_1
XFILLER_0_333 VGND VGND VPWR VPWR sky130_fd_sc_hd__decap_3
XFILLER_63_329 VGND VGND VPWR VPWR sky130_fd_sc_hd__decap_6
XTAP_TAPCELL_ROW_3_160 VGND VPWR sky130_fd_sc_hd__tapvpwrvgnd_1
XFILLER_0_377 VPWR VGND VPWR VGND sky130_ef_sc_hd__decap_12
XFILLER_16_267 VGND VGND VPWR VPWR sky130_fd_sc_hd__fill_2
XFILLER_17_82 VGND VGND VPWR VPWR sky130_fd_sc_hd__fill_2
XFILLER_33_92 VPWR VGND VPWR VGND sky130_ef_sc_hd__decap_12
XFILLER_3_193 VPWR VGND VPWR VGND sky130_ef_sc_hd__decap_12
XFILLER_12_3 VPWR VGND VPWR VGND sky130_ef_sc_hd__decap_12
XFILLER_54_307 VGND VGND VPWR VPWR sky130_fd_sc_hd__fill_1
XTAP_TAPCELL_ROW_17_262 VGND VPWR sky130_fd_sc_hd__tapvpwrvgnd_1
XTAP_TAPCELL_ROW_60_563 VGND VPWR sky130_fd_sc_hd__tapvpwrvgnd_1
XFILLER_30_270 VPWR VGND VPWR VGND sky130_ef_sc_hd__decap_12
X_0709_ net88 net14 _0090_ VGND VGND VPWR VPWR _0094_ sky130_fd_sc_hd__mux2_1
XFILLER_57_167 VGND VGND VPWR VPWR sky130_fd_sc_hd__fill_1
XTAP_TAPCELL_ROW_0_130 VGND VPWR sky130_fd_sc_hd__tapvpwrvgnd_1
XTAP_TAPCELL_ROW_0_141 VGND VPWR sky130_fd_sc_hd__tapvpwrvgnd_1
XFILLER_21_281 VPWR VGND VPWR VGND sky130_ef_sc_hd__decap_12
XTAP_TAPCELL_ROW_23_298 VGND VPWR sky130_fd_sc_hd__tapvpwrvgnd_1
XFILLER_48_101 VPWR VGND VPWR VGND sky130_ef_sc_hd__decap_12
XFILLER_0_141 VPWR VGND VPWR VGND sky130_ef_sc_hd__decap_12
XFILLER_63_137 VPWR VGND VPWR VGND sky130_ef_sc_hd__decap_12
XFILLER_36_307 VGND VGND VPWR VPWR sky130_fd_sc_hd__fill_1
XFILLER_28_81 VGND VGND VPWR VPWR sky130_fd_sc_hd__decap_3
X_0991_ _0253_ _0320_ _0322_ VGND VGND VPWR VPWR _0324_ sky130_fd_sc_hd__nand3_1
XFILLER_27_318 VGND VGND VPWR VPWR sky130_fd_sc_hd__decap_3
XFILLER_50_365 VGND VGND VPWR VPWR sky130_fd_sc_hd__decap_6
XFILLER_50_321 VGND VGND VPWR VPWR sky130_fd_sc_hd__fill_2
XFILLER_40_38 VPWR VGND VPWR VGND sky130_ef_sc_hd__decap_12
XTAP_TAPCELL_ROW_20_279 VGND VPWR sky130_fd_sc_hd__tapvpwrvgnd_1
XFILLER_45_148 VGND VGND VPWR VPWR sky130_fd_sc_hd__fill_1
XTAP_TAPCELL_ROW_28_335 VGND VPWR sky130_fd_sc_hd__tapvpwrvgnd_1
XFILLER_26_351 VPWR VGND VPWR VGND sky130_ef_sc_hd__decap_12
XFILLER_18_307 VGND VGND VPWR VPWR sky130_fd_sc_hd__fill_1
XFILLER_53_181 VPWR VGND VPWR VGND sky130_ef_sc_hd__decap_12
XTAP_TAPCELL_ROW_36_390 VGND VPWR sky130_fd_sc_hd__tapvpwrvgnd_1
XFILLER_30_93 VGND VGND VPWR VPWR sky130_fd_sc_hd__decap_3
Xinput9 rst VGND VGND VPWR VPWR net9 sky130_fd_sc_hd__clkbuf_4
XFILLER_39_91 VGND VGND VPWR VPWR sky130_fd_sc_hd__decap_8
X_1190_ _0465_ _0485_ _0484_ VGND VGND VPWR VPWR _0518_ sky130_fd_sc_hd__a21o_1
XFILLER_32_321 VGND VGND VPWR VPWR sky130_fd_sc_hd__fill_1
XFILLER_17_373 VPWR VGND VPWR VGND sky130_ef_sc_hd__decap_12
X_0974_ net65 net79 net81 VGND VGND VPWR VPWR _0307_ sky130_fd_sc_hd__and3_1
X_1457_ clknet_3_7__leaf_clk _0073_ VGND VGND VPWR VPWR core_out\[24\] sky130_fd_sc_hd__dfxtp_2
XFILLER_35_27 VPWR VGND VPWR VGND sky130_ef_sc_hd__decap_12
XFILLER_27_104 VGND VGND VPWR VPWR sky130_fd_sc_hd__decap_8
X_1388_ clknet_3_1__leaf_clk _0004_ VGND VGND VPWR VPWR core_a\[3\] sky130_fd_sc_hd__dfxtp_1
XFILLER_50_162 VPWR VGND VPWR VGND sky130_ef_sc_hd__decap_12
XFILLER_35_181 VPWR VGND VPWR VGND sky130_ef_sc_hd__decap_12
XTAP_TAPCELL_ROW_33_371 VGND VPWR sky130_fd_sc_hd__tapvpwrvgnd_1
XTAP_TAPCELL_ROW_25_316 VGND VPWR sky130_fd_sc_hd__tapvpwrvgnd_1
XFILLER_58_251 VGND VGND VPWR VPWR sky130_fd_sc_hd__fill_1
XFILLER_46_402 VGND VGND VPWR VPWR sky130_fd_sc_hd__fill_1
XFILLER_61_405 VGND VGND VPWR VPWR sky130_fd_sc_hd__fill_2
XFILLER_14_321 VPWR VGND VPWR VGND sky130_ef_sc_hd__decap_12
XFILLER_14_365 VPWR VGND VPWR VGND sky130_ef_sc_hd__decap_12
XFILLER_25_71 VGND VGND VPWR VPWR sky130_fd_sc_hd__decap_8
XFILLER_41_151 VGND VGND VPWR VPWR sky130_fd_sc_hd__fill_2
XFILLER_41_81 VPWR VGND VPWR VGND sky130_ef_sc_hd__decap_12
X_1311_ _0627_ _0628_ _0629_ VGND VGND VPWR VPWR _0630_ sky130_fd_sc_hd__o21ai_1
XFILLER_2_97 VPWR VGND VPWR VGND sky130_ef_sc_hd__decap_12
XFILLER_2_53 VPWR VGND VPWR VGND sky130_ef_sc_hd__decap_12
X_1242_ _0531_ _0542_ _0566_ VGND VGND VPWR VPWR _0568_ sky130_fd_sc_hd__or3b_1
XPHY_EDGE_ROW_10_Right_10 VGND VGND VPWR VPWR sky130_fd_sc_hd__decap_3
X_1173_ _0432_ _0500_ VGND VGND VPWR VPWR _0501_ sky130_fd_sc_hd__xor2_1
XFILLER_24_107 VGND VGND VPWR VPWR sky130_fd_sc_hd__decap_4
XFILLER_17_181 VPWR VGND VPWR VGND sky130_ef_sc_hd__decap_12
XFILLER_20_357 VGND VGND VPWR VPWR sky130_fd_sc_hd__decap_6
X_0957_ net96 _0290_ VGND VGND VPWR VPWR _0291_ sky130_fd_sc_hd__nand2_1
X_0888_ _0221_ _0222_ VGND VGND VPWR VPWR _0223_ sky130_fd_sc_hd__or2_1
XTAP_TAPCELL_ROW_30_352 VGND VPWR sky130_fd_sc_hd__tapvpwrvgnd_1
XFILLER_9_391 VGND VGND VPWR VPWR sky130_fd_sc_hd__fill_1
XFILLER_46_48 VGND VGND VPWR VPWR sky130_fd_sc_hd__decap_6
XFILLER_43_405 VGND VGND VPWR VPWR sky130_fd_sc_hd__fill_2
XFILLER_7_317 VPWR VGND VPWR VGND sky130_ef_sc_hd__decap_12
XFILLER_11_335 VGND VGND VPWR VPWR sky130_fd_sc_hd__fill_1
XFILLER_61_279 VGND VGND VPWR VPWR sky130_fd_sc_hd__fill_1
X_0742_ net83 net63 _0100_ net67 VGND VGND VPWR VPWR _0116_ sky130_fd_sc_hd__a22o_1
X_0811_ net65 net18 _0144_ VGND VGND VPWR VPWR _0152_ sky130_fd_sc_hd__mux2_1
Xinput12 wdata[1] VGND VGND VPWR VPWR net12 sky130_fd_sc_hd__buf_1
XFILLER_42_3 VGND VGND VPWR VPWR sky130_fd_sc_hd__decap_6
XFILLER_52_246 VGND VGND VPWR VPWR sky130_fd_sc_hd__decap_3
X_1087_ _0417_ VGND VGND VPWR VPWR _0418_ sky130_fd_sc_hd__inv_2
XFILLER_16_29 VPWR VGND VPWR VGND sky130_ef_sc_hd__decap_12
X_1156_ _0482_ _0483_ VGND VGND VPWR VPWR _0485_ sky130_fd_sc_hd__xor2_1
X_1225_ _0521_ _0522_ net121 _0519_ VGND VGND VPWR VPWR _0552_ sky130_fd_sc_hd__a31o_1
XFILLER_20_132 VGND VGND VPWR VPWR sky130_fd_sc_hd__decap_8
XFILLER_20_165 VGND VGND VPWR VPWR sky130_fd_sc_hd__decap_8
XFILLER_4_309 VPWR VGND VPWR VGND sky130_ef_sc_hd__decap_12
XTAP_TAPCELL_ROW_58_547 VGND VPWR sky130_fd_sc_hd__tapvpwrvgnd_1
XFILLER_57_69 VPWR VGND VPWR VGND sky130_ef_sc_hd__decap_12
XFILLER_28_265 VGND VGND VPWR VPWR sky130_fd_sc_hd__decap_4
XFILLER_43_279 VGND VGND VPWR VPWR sky130_fd_sc_hd__fill_1
XTAP_TAPCELL_ROW_41_425 VGND VPWR sky130_fd_sc_hd__tapvpwrvgnd_1
XFILLER_7_125 VPWR VGND VPWR VGND sky130_ef_sc_hd__decap_12
XFILLER_7_103 VGND VGND VPWR VPWR sky130_fd_sc_hd__decap_8
X_1010_ _0341_ _0338_ VGND VGND VPWR VPWR _0342_ sky130_fd_sc_hd__nand2b_1
XTAP_TAPCELL_ROW_6_180 VGND VPWR sky130_fd_sc_hd__tapvpwrvgnd_1
XFILLER_19_287 VPWR VGND VPWR VGND sky130_ef_sc_hd__decap_12
XFILLER_8_41 VPWR VGND VPWR VGND sky130_ef_sc_hd__decap_12
XFILLER_8_85 VGND VGND VPWR VPWR sky130_fd_sc_hd__decap_3
X_0725_ net132 _0100_ _0102_ _0104_ VGND VGND VPWR VPWR _0105_ sky130_fd_sc_hd__a211o_1
XFILLER_57_349 VPWR VGND VPWR VGND sky130_ef_sc_hd__decap_12
X_1208_ _0534_ VGND VGND VPWR VPWR _0535_ sky130_fd_sc_hd__inv_2
XTAP_TAPCELL_ROW_63_583 VGND VPWR sky130_fd_sc_hd__tapvpwrvgnd_1
XTAP_TAPCELL_ROW_55_528 VGND VPWR sky130_fd_sc_hd__tapvpwrvgnd_1
XFILLER_43_49 VGND VGND VPWR VPWR sky130_fd_sc_hd__decap_6
XFILLER_40_205 VGND VGND VPWR VPWR sky130_fd_sc_hd__decap_3
XFILLER_25_279 VGND VGND VPWR VPWR sky130_fd_sc_hd__fill_1
X_1139_ net66 net84 net86 _0081_ VGND VGND VPWR VPWR _0468_ sky130_fd_sc_hd__o2bb2a_1
XFILLER_4_139 VGND VGND VPWR VPWR sky130_fd_sc_hd__fill_1
XFILLER_0_389 VGND VGND VPWR VPWR sky130_fd_sc_hd__decap_3
XTAP_TAPCELL_ROW_3_161 VGND VPWR sky130_fd_sc_hd__tapvpwrvgnd_1
XPHY_EDGE_ROW_9_Left_74 VGND VGND VPWR VPWR sky130_fd_sc_hd__decap_3
XFILLER_16_246 VGND VGND VPWR VPWR sky130_fd_sc_hd__fill_1
XFILLER_17_72 VGND VGND VPWR VPWR sky130_fd_sc_hd__fill_1
XFILLER_31_238 VPWR VGND VPWR VGND sky130_ef_sc_hd__decap_12
XFILLER_31_205 VGND VGND VPWR VPWR sky130_fd_sc_hd__decap_3
XFILLER_8_401 VGND VGND VPWR VPWR sky130_fd_sc_hd__decap_6
XFILLER_3_161 VGND VGND VPWR VPWR sky130_fd_sc_hd__decap_6
XPHY_EDGE_ROW_8_Right_8 VGND VGND VPWR VPWR sky130_fd_sc_hd__decap_3
XFILLER_30_282 VPWR VGND VPWR VGND sky130_ef_sc_hd__decap_12
XPHY_EDGE_ROW_39_Right_39 VGND VGND VPWR VPWR sky130_fd_sc_hd__decap_3
XFILLER_38_16 VPWR VGND VPWR VGND sky130_ef_sc_hd__decap_12
X_0708_ net111 _0093_ VGND VGND VPWR VPWR _0003_ sky130_fd_sc_hd__and2_1
XFILLER_57_113 VPWR VGND VPWR VGND sky130_ef_sc_hd__decap_12
XFILLER_54_26 VGND VGND VPWR VPWR sky130_fd_sc_hd__fill_2
XFILLER_38_371 VGND VGND VPWR VPWR sky130_fd_sc_hd__decap_8
XTAP_TAPCELL_ROW_0_142 VGND VPWR sky130_fd_sc_hd__tapvpwrvgnd_1
XTAP_TAPCELL_ROW_0_131 VGND VPWR sky130_fd_sc_hd__tapvpwrvgnd_1
XFILLER_53_374 VPWR VGND VPWR VGND sky130_ef_sc_hd__decap_12
XPHY_EDGE_ROW_48_Right_48 VGND VGND VPWR VPWR sky130_fd_sc_hd__decap_3
XFILLER_13_205 VPWR VGND VPWR VGND sky130_ef_sc_hd__decap_12
XPHY_EDGE_ROW_57_Right_57 VGND VGND VPWR VPWR sky130_fd_sc_hd__decap_3
XFILLER_21_293 VPWR VGND VPWR VGND sky130_ef_sc_hd__decap_12
XTAP_TAPCELL_ROW_23_299 VGND VPWR sky130_fd_sc_hd__tapvpwrvgnd_1
XFILLER_48_113 VGND VGND VPWR VPWR sky130_fd_sc_hd__decap_6
XFILLER_0_153 VPWR VGND VPWR VGND sky130_ef_sc_hd__decap_12
XFILLER_0_197 VPWR VGND VPWR VGND sky130_ef_sc_hd__decap_12
XFILLER_63_149 VPWR VGND VPWR VGND sky130_ef_sc_hd__decap_12
XFILLER_63_105 VGND VGND VPWR VPWR sky130_fd_sc_hd__decap_6
XFILLER_44_352 VPWR VGND VPWR VGND sky130_ef_sc_hd__decap_12
XFILLER_44_341 VGND VGND VPWR VPWR sky130_fd_sc_hd__decap_8
XFILLER_29_393 VGND VGND VPWR VPWR sky130_fd_sc_hd__fill_2
X_0990_ _0253_ _0320_ _0322_ VGND VGND VPWR VPWR _0323_ sky130_fd_sc_hd__and3_1
XFILLER_8_253 VPWR VGND VPWR VGND sky130_ef_sc_hd__decap_12
XPHY_EDGE_ROW_59_Left_124 VGND VGND VPWR VPWR sky130_fd_sc_hd__decap_3
XFILLER_50_388 VGND VGND VPWR VPWR sky130_fd_sc_hd__decap_3
XFILLER_24_29 VPWR VGND VPWR VGND sky130_ef_sc_hd__decap_12
XFILLER_60_108 VPWR VGND VPWR VGND sky130_ef_sc_hd__decap_12
XFILLER_53_193 VPWR VGND VPWR VGND sky130_ef_sc_hd__decap_12
XTAP_TAPCELL_ROW_28_336 VGND VPWR sky130_fd_sc_hd__tapvpwrvgnd_1
XFILLER_26_363 VGND VGND VPWR VPWR sky130_fd_sc_hd__fill_1
XTAP_TAPCELL_ROW_36_391 VGND VPWR sky130_fd_sc_hd__tapvpwrvgnd_1
XTAP_TAPCELL_ROW_11_214 VGND VPWR sky130_fd_sc_hd__tapvpwrvgnd_1
XFILLER_30_83 VGND VGND VPWR VPWR sky130_fd_sc_hd__fill_1
XFILLER_5_223 VGND VGND VPWR VPWR sky130_fd_sc_hd__fill_1
XFILLER_36_149 VGND VGND VPWR VPWR sky130_fd_sc_hd__fill_2
XFILLER_36_116 VGND VGND VPWR VPWR sky130_fd_sc_hd__fill_1
XFILLER_51_119 VGND VGND VPWR VPWR sky130_fd_sc_hd__fill_1
XFILLER_44_171 VGND VGND VPWR VPWR sky130_fd_sc_hd__decap_8
XFILLER_17_385 VGND VGND VPWR VPWR sky130_fd_sc_hd__decap_6
X_0973_ net79 net81 net65 VGND VGND VPWR VPWR _0306_ sky130_fd_sc_hd__a21oi_1
XFILLER_59_208 VGND VGND VPWR VPWR sky130_fd_sc_hd__fill_1
X_1456_ clknet_3_7__leaf_clk _0072_ VGND VGND VPWR VPWR core_out\[23\] sky130_fd_sc_hd__dfxtp_1
XFILLER_19_18 VGND VGND VPWR VPWR sky130_fd_sc_hd__fill_1
X_1387_ clknet_3_1__leaf_clk _0003_ VGND VGND VPWR VPWR core_a\[2\] sky130_fd_sc_hd__dfxtp_1
XFILLER_35_39 VPWR VGND VPWR VGND sky130_ef_sc_hd__decap_12
XTAP_TAPCELL_ROW_25_317 VGND VPWR sky130_fd_sc_hd__tapvpwrvgnd_1
XFILLER_50_174 VGND VGND VPWR VPWR sky130_fd_sc_hd__decap_8
XFILLER_50_141 VGND VGND VPWR VPWR sky130_fd_sc_hd__decap_8
XFILLER_35_193 VGND VGND VPWR VPWR sky130_fd_sc_hd__decap_8
XTAP_TAPCELL_ROW_33_372 VGND VPWR sky130_fd_sc_hd__tapvpwrvgnd_1
XFILLER_23_333 VGND VGND VPWR VPWR sky130_fd_sc_hd__decap_3
XFILLER_41_163 VGND VGND VPWR VPWR sky130_fd_sc_hd__decap_4
XFILLER_14_333 VPWR VGND VPWR VGND sky130_ef_sc_hd__decap_12
XFILLER_14_377 VPWR VGND VPWR VGND sky130_ef_sc_hd__decap_12
XFILLER_41_93 VPWR VGND VPWR VGND sky130_ef_sc_hd__decap_12
X_1310_ _0628_ _0627_ net102 VGND VGND VPWR VPWR _0629_ sky130_fd_sc_hd__a21boi_1
XFILLER_44_7 VGND VGND VPWR VPWR sky130_fd_sc_hd__fill_2
XFILLER_1_281 VPWR VGND VPWR VGND sky130_ef_sc_hd__decap_12
X_1241_ _0531_ _0542_ _0566_ VGND VGND VPWR VPWR _0567_ sky130_fd_sc_hd__o21ba_1
XPHY_EDGE_ROW_22_Left_87 VGND VGND VPWR VPWR sky130_fd_sc_hd__decap_3
XFILLER_2_65 VPWR VGND VPWR VGND sky130_ef_sc_hd__decap_12
X_1172_ net68 _0474_ _0499_ VGND VGND VPWR VPWR _0500_ sky130_fd_sc_hd__a21oi_2
X_0956_ _0288_ _0289_ VGND VGND VPWR VPWR _0290_ sky130_fd_sc_hd__xnor2_1
XFILLER_32_185 VGND VGND VPWR VPWR sky130_fd_sc_hd__decap_8
XFILLER_32_141 VGND VGND VPWR VPWR sky130_fd_sc_hd__decap_8
XTAP_TAPCELL_ROW_30_353 VGND VPWR sky130_fd_sc_hd__tapvpwrvgnd_1
XFILLER_17_193 VGND VGND VPWR VPWR sky130_fd_sc_hd__decap_8
X_0887_ net73 net90 net93 net71 VGND VGND VPWR VPWR _0222_ sky130_fd_sc_hd__a22oi_1
XFILLER_55_200 VGND VGND VPWR VPWR sky130_fd_sc_hd__decap_6
X_1439_ clknet_3_3__leaf_clk _0055_ VGND VGND VPWR VPWR core_out\[6\] sky130_fd_sc_hd__dfxtp_1
XFILLER_46_16 VPWR VGND VPWR VGND sky130_ef_sc_hd__decap_12
XFILLER_62_15 VPWR VGND VPWR VGND sky130_ef_sc_hd__decap_12
XFILLER_55_299 VPWR VGND VPWR VGND sky130_ef_sc_hd__decap_12
XFILLER_15_108 VGND VGND VPWR VPWR sky130_fd_sc_hd__decap_4
XFILLER_23_152 VPWR VGND VPWR VGND sky130_ef_sc_hd__decap_12
XFILLER_7_329 VGND VGND VPWR VPWR sky130_fd_sc_hd__decap_6
XFILLER_23_185 VPWR VGND VPWR VGND sky130_ef_sc_hd__decap_12
XFILLER_2_3 VPWR VGND VPWR VGND sky130_ef_sc_hd__decap_12
XFILLER_61_225 VPWR VGND VPWR VGND sky130_ef_sc_hd__decap_12
XTAP_TAPCELL_ROW_44_445 VGND VPWR sky130_fd_sc_hd__tapvpwrvgnd_1
X_0810_ net108 _0151_ VGND VGND VPWR VPWR _0047_ sky130_fd_sc_hd__and2_1
XFILLER_14_141 VPWR VGND VPWR VGND sky130_ef_sc_hd__decap_12
Xinput13 wdata[2] VGND VGND VPWR VPWR net13 sky130_fd_sc_hd__clkbuf_1
X_0741_ net139 net107 _0115_ net110 VGND VGND VPWR VPWR _0014_ sky130_fd_sc_hd__o211a_1
XFILLER_35_3 VPWR VGND VPWR VGND sky130_ef_sc_hd__decap_12
X_1224_ _0548_ _0549_ VGND VGND VPWR VPWR _0551_ sky130_fd_sc_hd__xnor2_2
X_1086_ core_out\[9\] _0416_ VGND VGND VPWR VPWR _0417_ sky130_fd_sc_hd__nand2_1
X_1155_ _0482_ _0483_ VGND VGND VPWR VPWR _0484_ sky130_fd_sc_hd__and2_1
X_0939_ _0270_ _0271_ _0261_ VGND VGND VPWR VPWR _0273_ sky130_fd_sc_hd__a21o_1
XFILLER_32_29 VPWR VGND VPWR VGND sky130_ef_sc_hd__decap_12
XTAP_TAPCELL_ROW_58_548 VGND VPWR sky130_fd_sc_hd__tapvpwrvgnd_1
XFILLER_43_225 VPWR VGND VPWR VGND sky130_ef_sc_hd__decap_12
XTAP_TAPCELL_ROW_41_426 VGND VPWR sky130_fd_sc_hd__tapvpwrvgnd_1
XFILLER_7_137 VGND VGND VPWR VPWR sky130_fd_sc_hd__decap_8
XFILLER_59_391 VGND VGND VPWR VPWR sky130_fd_sc_hd__fill_1
XTAP_TAPCELL_ROW_6_181 VGND VPWR sky130_fd_sc_hd__tapvpwrvgnd_1
XFILLER_47_81 VGND VGND VPWR VPWR sky130_fd_sc_hd__decap_8
XFILLER_19_299 VPWR VGND VPWR VGND sky130_ef_sc_hd__decap_12
XFILLER_8_53 VPWR VGND VPWR VGND sky130_ef_sc_hd__decap_12
X_0724_ net94 net64 net62 core_out\[0\] VGND VGND VPWR VPWR _0104_ sky130_fd_sc_hd__a22o_1
XFILLER_6_181 VGND VGND VPWR VPWR sky130_fd_sc_hd__fill_1
XPHY_EDGE_ROW_40_Left_105 VGND VGND VPWR VPWR sky130_fd_sc_hd__decap_3
XFILLER_27_29 VGND VGND VPWR VPWR sky130_fd_sc_hd__decap_8
X_1207_ net68 _0473_ _0434_ VGND VGND VPWR VPWR _0534_ sky130_fd_sc_hd__a21oi_2
XPHY_EDGE_ROW_25_Left_90 VGND VGND VPWR VPWR sky130_fd_sc_hd__decap_3
XTAP_TAPCELL_ROW_63_584 VGND VPWR sky130_fd_sc_hd__tapvpwrvgnd_1
X_1138_ net86 net84 net66 net65 VGND VGND VPWR VPWR _0467_ sky130_fd_sc_hd__and4b_1
X_1069_ _0396_ _0395_ _0397_ VGND VGND VPWR VPWR _0400_ sky130_fd_sc_hd__a21o_1
Xclone16 core_b\[0\] VGND VGND VPWR VPWR net132 sky130_fd_sc_hd__clkbuf_1
XFILLER_56_361 VGND VGND VPWR VPWR sky130_fd_sc_hd__decap_3
XTAP_TAPCELL_ROW_3_162 VGND VPWR sky130_fd_sc_hd__tapvpwrvgnd_1
XFILLER_16_236 VGND VGND VPWR VPWR sky130_fd_sc_hd__fill_1
XFILLER_54_309 VPWR VGND VPWR VGND sky130_ef_sc_hd__decap_12
XFILLER_47_361 VPWR VGND VPWR VGND sky130_ef_sc_hd__decap_12
XFILLER_30_294 VPWR VGND VPWR VGND sky130_ef_sc_hd__decap_12
X_0707_ net91 net13 _0090_ VGND VGND VPWR VPWR _0093_ sky130_fd_sc_hd__mux2_1
XFILLER_57_125 VPWR VGND VPWR VGND sky130_ef_sc_hd__decap_12
XFILLER_57_169 VPWR VGND VPWR VGND sky130_ef_sc_hd__decap_12
XFILLER_38_361 VGND VGND VPWR VPWR sky130_fd_sc_hd__decap_3
XTAP_TAPCELL_ROW_0_143 VGND VPWR sky130_fd_sc_hd__tapvpwrvgnd_1
XTAP_TAPCELL_ROW_0_132 VGND VPWR sky130_fd_sc_hd__tapvpwrvgnd_1
XFILLER_53_386 VGND VGND VPWR VPWR sky130_fd_sc_hd__decap_6
XFILLER_13_217 VGND VGND VPWR VPWR sky130_fd_sc_hd__decap_6
XFILLER_5_405 VGND VGND VPWR VPWR sky130_fd_sc_hd__fill_2
XFILLER_36_309 VPWR VGND VPWR VGND sky130_ef_sc_hd__decap_12
XFILLER_28_61 VGND VGND VPWR VPWR sky130_fd_sc_hd__fill_1
XFILLER_0_165 VGND VGND VPWR VPWR sky130_fd_sc_hd__decap_3
XFILLER_44_93 VGND VGND VPWR VPWR sky130_fd_sc_hd__decap_6
XFILLER_8_221 VPWR VGND VPWR VGND sky130_ef_sc_hd__decap_12
XFILLER_8_265 VPWR VGND VPWR VGND sky130_ef_sc_hd__decap_12
XFILLER_54_139 VGND VGND VPWR VPWR sky130_fd_sc_hd__fill_1
XFILLER_39_169 VGND VGND VPWR VPWR sky130_fd_sc_hd__fill_2
XFILLER_39_136 VGND VGND VPWR VPWR sky130_fd_sc_hd__decap_8
XFILLER_10_209 VPWR VGND VPWR VGND sky130_ef_sc_hd__decap_12
XFILLER_40_29 VGND VGND VPWR VPWR sky130_fd_sc_hd__fill_2
XFILLER_58_401 VGND VGND VPWR VPWR sky130_fd_sc_hd__decap_6
XFILLER_18_309 VPWR VGND VPWR VGND sky130_ef_sc_hd__decap_12
XFILLER_53_161 VGND VGND VPWR VPWR sky130_fd_sc_hd__decap_6
XTAP_TAPCELL_ROW_36_392 VGND VPWR sky130_fd_sc_hd__tapvpwrvgnd_1
XTAP_TAPCELL_ROW_28_337 VGND VPWR sky130_fd_sc_hd__tapvpwrvgnd_1
XTAP_TAPCELL_ROW_11_215 VGND VPWR sky130_fd_sc_hd__tapvpwrvgnd_1
XFILLER_14_41 VGND VGND VPWR VPWR sky130_fd_sc_hd__decap_6
XFILLER_14_85 VPWR VGND VPWR VGND sky130_ef_sc_hd__decap_12
XFILLER_49_401 VGND VGND VPWR VPWR sky130_fd_sc_hd__fill_2
XFILLER_5_279 VGND VGND VPWR VPWR sky130_fd_sc_hd__fill_1
XFILLER_55_81 VPWR VGND VPWR VGND sky130_ef_sc_hd__decap_12
XFILLER_51_109 VGND VGND VPWR VPWR sky130_fd_sc_hd__decap_3
XFILLER_36_139 VGND VGND VPWR VPWR sky130_fd_sc_hd__fill_1
XFILLER_29_180 VGND VGND VPWR VPWR sky130_fd_sc_hd__decap_8
XFILLER_32_389 VGND VGND VPWR VPWR sky130_fd_sc_hd__fill_1
XFILLER_32_345 VGND VGND VPWR VPWR sky130_fd_sc_hd__decap_3
X_0972_ _0257_ _0304_ VGND VGND VPWR VPWR _0305_ sky130_fd_sc_hd__xor2_1
X_1455_ clknet_3_7__leaf_clk _0071_ VGND VGND VPWR VPWR core_out\[22\] sky130_fd_sc_hd__dfxtp_1
X_1386_ clknet_3_0__leaf_clk _0002_ VGND VGND VPWR VPWR core_a\[1\] sky130_fd_sc_hd__dfxtp_1
XTAP_TAPCELL_ROW_25_318 VGND VPWR sky130_fd_sc_hd__tapvpwrvgnd_1
XFILLER_50_197 VPWR VGND VPWR VGND sky130_ef_sc_hd__decap_12
XTAP_TAPCELL_ROW_33_373 VGND VPWR sky130_fd_sc_hd__tapvpwrvgnd_1
XFILLER_58_253 VPWR VGND VPWR VGND sky130_ef_sc_hd__decap_12
XFILLER_41_131 VPWR VGND VPWR VGND sky130_ef_sc_hd__decap_12
XFILLER_14_301 VGND VGND VPWR VPWR sky130_fd_sc_hd__decap_6
XFILLER_14_345 VPWR VGND VPWR VGND sky130_ef_sc_hd__decap_12
XFILLER_14_389 VPWR VGND VPWR VGND sky130_ef_sc_hd__decap_12
XFILLER_2_77 VGND VGND VPWR VPWR sky130_fd_sc_hd__decap_6
XFILLER_1_293 VPWR VGND VPWR VGND sky130_ef_sc_hd__decap_12
X_1240_ _0533_ _0565_ VGND VGND VPWR VPWR _0566_ sky130_fd_sc_hd__xor2_1
X_1171_ net68 net80 _0435_ _0473_ VGND VGND VPWR VPWR _0499_ sky130_fd_sc_hd__a22oi_1
XFILLER_64_223 VGND VGND VPWR VPWR sky130_fd_sc_hd__fill_1
X_0955_ _0248_ _0250_ _0247_ VGND VGND VPWR VPWR _0289_ sky130_fd_sc_hd__a21o_1
X_0886_ net71 net73 net90 net92 VGND VGND VPWR VPWR _0221_ sky130_fd_sc_hd__and4_1
XFILLER_32_197 VGND VGND VPWR VPWR sky130_fd_sc_hd__decap_8
XFILLER_9_393 VPWR VGND VPWR VGND sky130_ef_sc_hd__decap_12
XFILLER_55_245 VGND VGND VPWR VPWR sky130_fd_sc_hd__fill_1
X_1369_ core_out\[30\] net52 VGND VGND VPWR VPWR _0679_ sky130_fd_sc_hd__and2_1
X_1438_ clknet_3_3__leaf_clk _0054_ VGND VGND VPWR VPWR core_out\[5\] sky130_fd_sc_hd__dfxtp_1
XFILLER_62_27 VGND VGND VPWR VPWR sky130_fd_sc_hd__fill_1
XFILLER_55_289 VGND VGND VPWR VPWR sky130_fd_sc_hd__decap_3
XFILLER_11_337 VPWR VGND VPWR VGND sky130_ef_sc_hd__decap_12
XFILLER_23_164 VGND VGND VPWR VPWR sky130_fd_sc_hd__decap_4
XFILLER_23_197 VPWR VGND VPWR VGND sky130_ef_sc_hd__decap_12
XFILLER_11_75 VGND VGND VPWR VPWR sky130_fd_sc_hd__decap_3
XFILLER_61_237 VGND VGND VPWR VPWR sky130_fd_sc_hd__decap_6
XTAP_TAPCELL_ROW_44_446 VGND VPWR sky130_fd_sc_hd__tapvpwrvgnd_1
X_0740_ core_out\[5\] net62 _0114_ _0102_ VGND VGND VPWR VPWR _0115_ sky130_fd_sc_hd__a211o_1
Xinput14 wdata[3] VGND VGND VPWR VPWR net14 sky130_fd_sc_hd__clkbuf_1
XFILLER_14_153 VGND VGND VPWR VPWR sky130_fd_sc_hd__decap_3
XFILLER_14_164 VGND VGND VPWR VPWR sky130_fd_sc_hd__fill_2
XFILLER_14_197 VPWR VGND VPWR VGND sky130_ef_sc_hd__decap_12
XFILLER_6_363 VGND VGND VPWR VPWR sky130_fd_sc_hd__fill_1
XFILLER_28_3 VGND VGND VPWR VPWR sky130_fd_sc_hd__decap_6
X_1223_ _0549_ _0548_ VGND VGND VPWR VPWR _0550_ sky130_fd_sc_hd__and2b_1
X_1154_ _0430_ _0443_ _0442_ VGND VGND VPWR VPWR _0483_ sky130_fd_sc_hd__o21ai_1
XFILLER_52_259 VGND VGND VPWR VPWR sky130_fd_sc_hd__fill_1
XFILLER_52_226 VGND VGND VPWR VPWR sky130_fd_sc_hd__fill_2
XFILLER_37_278 VGND VGND VPWR VPWR sky130_fd_sc_hd__fill_2
X_1085_ _0414_ _0415_ VGND VGND VPWR VPWR _0416_ sky130_fd_sc_hd__xnor2_1
X_0869_ _0178_ _0180_ _0179_ VGND VGND VPWR VPWR _0205_ sky130_fd_sc_hd__o21bai_1
X_0938_ _0261_ _0270_ _0271_ VGND VGND VPWR VPWR _0272_ sky130_fd_sc_hd__nand3_1
XFILLER_20_189 VGND VGND VPWR VPWR sky130_fd_sc_hd__decap_6
XTAP_TAPCELL_ROW_58_549 VGND VPWR sky130_fd_sc_hd__tapvpwrvgnd_1
XFILLER_43_237 VPWR VGND VPWR VGND sky130_ef_sc_hd__decap_12
XFILLER_51_281 VGND VGND VPWR VPWR sky130_fd_sc_hd__decap_8
XTAP_TAPCELL_ROW_41_427 VGND VPWR sky130_fd_sc_hd__tapvpwrvgnd_1
XFILLER_7_149 VGND VGND VPWR VPWR sky130_fd_sc_hd__fill_1
XTAP_TAPCELL_ROW_6_182 VGND VPWR sky130_fd_sc_hd__tapvpwrvgnd_1
XFILLER_19_245 VGND VGND VPWR VPWR sky130_fd_sc_hd__fill_1
XFILLER_63_81 VPWR VGND VPWR VGND sky130_ef_sc_hd__decap_12
X_0723_ _0087_ _0099_ VGND VGND VPWR VPWR _0103_ sky130_fd_sc_hd__nor2_2
XFILLER_8_65 VGND VGND VPWR VPWR sky130_fd_sc_hd__fill_2
X_1206_ _0531_ _0532_ VGND VGND VPWR VPWR _0533_ sky130_fd_sc_hd__nor2_1
X_1137_ _0436_ _0437_ VGND VGND VPWR VPWR _0466_ sky130_fd_sc_hd__nand2_1
XFILLER_25_204 VGND VGND VPWR VPWR sky130_fd_sc_hd__decap_3
XFILLER_43_29 VGND VGND VPWR VPWR sky130_fd_sc_hd__fill_2
XFILLER_40_218 VGND VGND VPWR VPWR sky130_fd_sc_hd__decap_8
XFILLER_33_281 VPWR VGND VPWR VGND sky130_ef_sc_hd__decap_12
X_1068_ net74 net130 VGND VGND VPWR VPWR _0399_ sky130_fd_sc_hd__nand2_1
XFILLER_48_318 VPWR VGND VPWR VGND sky130_ef_sc_hd__decap_12
XFILLER_48_307 VGND VGND VPWR VPWR sky130_fd_sc_hd__fill_1
XTAP_TAPCELL_ROW_3_163 VGND VPWR sky130_fd_sc_hd__tapvpwrvgnd_1
XFILLER_17_30 VPWR VGND VPWR VGND sky130_ef_sc_hd__decap_12
XFILLER_33_73 VPWR VGND VPWR VGND sky130_ef_sc_hd__decap_12
XFILLER_47_373 VPWR VGND VPWR VGND sky130_ef_sc_hd__decap_12
XFILLER_62_365 VPWR VGND VPWR VGND sky130_ef_sc_hd__decap_12
XFILLER_30_251 VGND VGND VPWR VPWR sky130_fd_sc_hd__fill_1
XFILLER_15_281 VPWR VGND VPWR VGND sky130_ef_sc_hd__decap_12
X_0706_ net109 _0092_ VGND VGND VPWR VPWR _0002_ sky130_fd_sc_hd__and2_1
XFILLER_57_137 VPWR VGND VPWR VGND sky130_ef_sc_hd__decap_12
XFILLER_38_29 VPWR VGND VPWR VGND sky130_ef_sc_hd__decap_12
XTAP_TAPCELL_ROW_51_500 VGND VPWR sky130_fd_sc_hd__tapvpwrvgnd_1
XTAP_TAPCELL_ROW_0_133 VGND VPWR sky130_fd_sc_hd__tapvpwrvgnd_1
XFILLER_44_321 VPWR VGND VPWR VGND sky130_ef_sc_hd__decap_12
XFILLER_44_83 VGND VGND VPWR VPWR sky130_fd_sc_hd__fill_1
XFILLER_44_61 VPWR VGND VPWR VGND sky130_ef_sc_hd__decap_12
XFILLER_12_240 VGND VGND VPWR VPWR sky130_fd_sc_hd__decap_8
XTAP_TAPCELL_ROW_14_235 VGND VPWR sky130_fd_sc_hd__tapvpwrvgnd_1
XFILLER_5_55 VGND VGND VPWR VPWR sky130_fd_sc_hd__fill_1
XFILLER_8_233 VPWR VGND VPWR VGND sky130_ef_sc_hd__decap_12
XFILLER_8_277 VPWR VGND VPWR VGND sky130_ef_sc_hd__decap_12
XFILLER_12_273 VPWR VGND VPWR VGND sky130_ef_sc_hd__decap_12
XFILLER_10_3 VPWR VGND VPWR VGND sky130_ef_sc_hd__decap_12
XFILLER_62_173 VGND VGND VPWR VPWR sky130_fd_sc_hd__decap_3
XFILLER_47_181 VPWR VGND VPWR VGND sky130_ef_sc_hd__decap_12
XFILLER_35_354 VGND VGND VPWR VPWR sky130_fd_sc_hd__fill_2
XTAP_TAPCELL_ROW_28_338 VGND VPWR sky130_fd_sc_hd__tapvpwrvgnd_1
XTAP_TAPCELL_ROW_36_393 VGND VPWR sky130_fd_sc_hd__tapvpwrvgnd_1
XFILLER_30_63 VPWR VGND VPWR VGND sky130_ef_sc_hd__decap_12
XFILLER_5_225 VPWR VGND VPWR VGND sky130_ef_sc_hd__decap_12
XTAP_TAPCELL_ROW_11_216 VGND VPWR sky130_fd_sc_hd__tapvpwrvgnd_1
XFILLER_14_97 VPWR VGND VPWR VGND sky130_ef_sc_hd__decap_12
XFILLER_30_85 VGND VGND VPWR VPWR sky130_fd_sc_hd__decap_8
XFILLER_64_405 VGND VGND VPWR VPWR sky130_fd_sc_hd__fill_2
XFILLER_55_93 VPWR VGND VPWR VGND sky130_ef_sc_hd__decap_12
XFILLER_44_184 VPWR VGND VPWR VGND sky130_ef_sc_hd__decap_12
X_0971_ _0302_ _0303_ VGND VGND VPWR VPWR _0304_ sky130_fd_sc_hd__nand2_1
XFILLER_58_3 VPWR VGND VPWR VGND sky130_ef_sc_hd__decap_12
X_1454_ clknet_3_7__leaf_clk _0070_ VGND VGND VPWR VPWR core_out\[21\] sky130_fd_sc_hd__dfxtp_1
XFILLER_55_405 VGND VGND VPWR VPWR sky130_fd_sc_hd__fill_2
X_1385_ clknet_3_0__leaf_clk _0001_ VGND VGND VPWR VPWR core_a\[0\] sky130_fd_sc_hd__dfxtp_1
XTAP_TAPCELL_ROW_33_374 VGND VPWR sky130_fd_sc_hd__tapvpwrvgnd_1
XFILLER_58_221 VPWR VGND VPWR VGND sky130_ef_sc_hd__decap_12
XFILLER_41_143 VGND VGND VPWR VPWR sky130_fd_sc_hd__decap_8
XFILLER_26_195 VGND VGND VPWR VPWR sky130_fd_sc_hd__fill_1
XFILLER_14_357 VGND VGND VPWR VPWR sky130_fd_sc_hd__decap_6
XFILLER_37_405 VGND VGND VPWR VPWR sky130_fd_sc_hd__fill_2
XFILLER_1_261 VPWR VGND VPWR VGND sky130_ef_sc_hd__decap_12
X_1170_ _0466_ _0469_ _0471_ VGND VGND VPWR VPWR _0498_ sky130_fd_sc_hd__a21bo_1
XFILLER_64_268 VGND VGND VPWR VPWR sky130_fd_sc_hd__decap_8
XTAP_TAPCELL_ROW_47_466 VGND VPWR sky130_fd_sc_hd__tapvpwrvgnd_1
X_0885_ net110 _0220_ VGND VGND VPWR VPWR _0053_ sky130_fd_sc_hd__and2_1
X_0954_ _0286_ _0287_ VGND VGND VPWR VPWR _0288_ sky130_fd_sc_hd__and2b_1
XFILLER_9_361 VPWR VGND VPWR VGND sky130_ef_sc_hd__decap_12
X_1437_ clknet_3_2__leaf_clk _0053_ VGND VGND VPWR VPWR core_out\[4\] sky130_fd_sc_hd__dfxtp_1
XFILLER_55_279 VGND VGND VPWR VPWR sky130_fd_sc_hd__fill_1
X_1368_ core_out\[30\] net52 VGND VGND VPWR VPWR _0678_ sky130_fd_sc_hd__nor2_1
XFILLER_46_29 VGND VGND VPWR VPWR sky130_fd_sc_hd__decap_3
X_1299_ _0604_ _0597_ _0609_ _0614_ VGND VGND VPWR VPWR _0619_ sky130_fd_sc_hd__or4_4
XFILLER_11_305 VPWR VGND VPWR VGND sky130_ef_sc_hd__decap_12
XFILLER_11_349 VPWR VGND VPWR VGND sky130_ef_sc_hd__decap_12
XFILLER_19_405 VGND VGND VPWR VPWR sky130_fd_sc_hd__fill_2
XTAP_TAPCELL_ROW_44_447 VGND VPWR sky130_fd_sc_hd__tapvpwrvgnd_1
XFILLER_14_121 VPWR VGND VPWR VGND sky130_ef_sc_hd__decap_12
Xinput15 wdata[4] VGND VGND VPWR VPWR net15 sky130_fd_sc_hd__clkbuf_1
XFILLER_52_205 VGND VGND VPWR VPWR sky130_fd_sc_hd__decap_4
X_1084_ _0336_ _0374_ _0372_ VGND VGND VPWR VPWR _0415_ sky130_fd_sc_hd__a21o_1
X_1222_ _0498_ _0516_ _0514_ VGND VGND VPWR VPWR _0549_ sky130_fd_sc_hd__a21oi_1
X_1153_ _0472_ _0480_ VGND VGND VPWR VPWR _0482_ sky130_fd_sc_hd__xor2_1
X_0868_ _0201_ _0202_ _0200_ VGND VGND VPWR VPWR _0204_ sky130_fd_sc_hd__o21ai_1
X_0937_ _0267_ _0268_ _0269_ VGND VGND VPWR VPWR _0271_ sky130_fd_sc_hd__a21o_1
X_0799_ net77 net12 _0144_ VGND VGND VPWR VPWR _0146_ sky130_fd_sc_hd__mux2_1
XFILLER_43_249 VPWR VGND VPWR VGND sky130_ef_sc_hd__decap_12
XFILLER_51_260 VPWR VGND VPWR VGND sky130_ef_sc_hd__decap_12
XTAP_TAPCELL_ROW_41_428 VGND VPWR sky130_fd_sc_hd__tapvpwrvgnd_1
XFILLER_11_113 VGND VGND VPWR VPWR sky130_fd_sc_hd__decap_6
XFILLER_59_393 VPWR VGND VPWR VGND sky130_ef_sc_hd__decap_12
XTAP_TAPCELL_ROW_6_183 VGND VPWR sky130_fd_sc_hd__tapvpwrvgnd_1
XFILLER_19_279 VGND VGND VPWR VPWR sky130_fd_sc_hd__fill_1
XFILLER_63_93 VPWR VGND VPWR VGND sky130_ef_sc_hd__decap_12
Xclkbuf_3_4__f_clk clknet_0_clk VGND VGND VPWR VPWR clknet_3_4__leaf_clk sky130_fd_sc_hd__clkbuf_16
X_0722_ net19 net10 VGND VGND VPWR VPWR _0102_ sky130_fd_sc_hd__nand2b_4
XFILLER_40_3 VGND VGND VPWR VPWR sky130_fd_sc_hd__fill_2
X_1205_ _0398_ _0432_ _0500_ VGND VGND VPWR VPWR _0532_ sky130_fd_sc_hd__nor3_1
X_1067_ net74 net130 VGND VGND VPWR VPWR _0398_ sky130_fd_sc_hd__and2_1
X_1136_ _0385_ _0429_ _0428_ VGND VGND VPWR VPWR _0465_ sky130_fd_sc_hd__a21o_1
XFILLER_33_293 VPWR VGND VPWR VGND sky130_ef_sc_hd__decap_12
XFILLER_4_109 VPWR VGND VPWR VGND sky130_ef_sc_hd__decap_12
XFILLER_0_337 VPWR VGND VPWR VGND sky130_ef_sc_hd__decap_12
XTAP_TAPCELL_ROW_3_164 VGND VPWR sky130_fd_sc_hd__tapvpwrvgnd_1
XTAP_TAPCELL_ROW_54_520 VGND VPWR sky130_fd_sc_hd__tapvpwrvgnd_1
XFILLER_17_42 VGND VGND VPWR VPWR sky130_fd_sc_hd__decap_3
XFILLER_47_385 VGND VGND VPWR VPWR sky130_fd_sc_hd__decap_6
XFILLER_62_377 VPWR VGND VPWR VGND sky130_ef_sc_hd__decap_12
XFILLER_15_293 VPWR VGND VPWR VGND sky130_ef_sc_hd__decap_12
X_0705_ net92 net12 _0090_ VGND VGND VPWR VPWR _0092_ sky130_fd_sc_hd__mux2_1
XFILLER_57_149 VPWR VGND VPWR VGND sky130_ef_sc_hd__decap_12
XFILLER_57_105 VGND VGND VPWR VPWR sky130_fd_sc_hd__fill_1
XFILLER_54_29 VPWR VGND VPWR VGND sky130_ef_sc_hd__decap_12
XFILLER_54_18 VGND VGND VPWR VPWR sky130_fd_sc_hd__decap_8
X_1119_ _0423_ _0448_ VGND VGND VPWR VPWR _0449_ sky130_fd_sc_hd__nand2b_1
XTAP_TAPCELL_ROW_0_134 VGND VPWR sky130_fd_sc_hd__tapvpwrvgnd_1
XPHY_EDGE_ROW_17_Right_17 VGND VGND VPWR VPWR sky130_fd_sc_hd__decap_3
XPHY_EDGE_ROW_26_Right_26 VGND VGND VPWR VPWR sky130_fd_sc_hd__decap_3
XFILLER_48_138 VGND VGND VPWR VPWR sky130_fd_sc_hd__fill_2
XFILLER_44_333 VGND VGND VPWR VPWR sky130_fd_sc_hd__decap_4
XFILLER_28_85 VPWR VGND VPWR VGND sky130_ef_sc_hd__decap_12
XFILLER_28_41 VPWR VGND VPWR VGND sky130_ef_sc_hd__decap_12
XFILLER_44_73 VGND VGND VPWR VPWR sky130_fd_sc_hd__decap_6
XPHY_EDGE_ROW_35_Right_35 VGND VGND VPWR VPWR sky130_fd_sc_hd__decap_3
XFILLER_8_212 VGND VGND VPWR VPWR sky130_fd_sc_hd__decap_4
XFILLER_8_245 VGND VGND VPWR VPWR sky130_fd_sc_hd__decap_6
XFILLER_12_285 VPWR VGND VPWR VGND sky130_ef_sc_hd__decap_12
XTAP_TAPCELL_ROW_14_236 VGND VPWR sky130_fd_sc_hd__tapvpwrvgnd_1
XFILLER_60_83 VGND VGND VPWR VPWR sky130_fd_sc_hd__fill_1
XFILLER_8_289 VPWR VGND VPWR VGND sky130_ef_sc_hd__decap_12
XTAP_TAPCELL_ROW_22_291 VGND VPWR sky130_fd_sc_hd__tapvpwrvgnd_1
XPHY_EDGE_ROW_44_Right_44 VGND VGND VPWR VPWR sky130_fd_sc_hd__decap_3
XFILLER_62_141 VPWR VGND VPWR VGND sky130_ef_sc_hd__decap_12
XPHY_EDGE_ROW_53_Right_53 VGND VGND VPWR VPWR sky130_fd_sc_hd__decap_3
XFILLER_47_193 VPWR VGND VPWR VGND sky130_ef_sc_hd__decap_12
XFILLER_35_344 VGND VGND VPWR VPWR sky130_fd_sc_hd__fill_1
XPHY_EDGE_ROW_62_Right_62 VGND VGND VPWR VPWR sky130_fd_sc_hd__decap_3
XFILLER_49_18 VGND VGND VPWR VPWR sky130_fd_sc_hd__fill_1
XPHY_EDGE_ROW_37_Left_102 VGND VGND VPWR VPWR sky130_fd_sc_hd__decap_3
XFILLER_45_119 VPWR VGND VPWR VGND sky130_ef_sc_hd__decap_12
XTAP_TAPCELL_ROW_28_339 VGND VPWR sky130_fd_sc_hd__tapvpwrvgnd_1
XPHY_EDGE_ROW_46_Left_111 VGND VGND VPWR VPWR sky130_fd_sc_hd__decap_3
XTAP_TAPCELL_ROW_36_394 VGND VPWR sky130_fd_sc_hd__tapvpwrvgnd_1
XTAP_TAPCELL_ROW_11_217 VGND VPWR sky130_fd_sc_hd__tapvpwrvgnd_1
XPHY_EDGE_ROW_55_Left_120 VGND VGND VPWR VPWR sky130_fd_sc_hd__decap_3
XFILLER_30_75 VGND VGND VPWR VPWR sky130_fd_sc_hd__decap_8
XFILLER_5_237 VPWR VGND VPWR VGND sky130_ef_sc_hd__decap_12
XFILLER_36_108 VGND VGND VPWR VPWR sky130_fd_sc_hd__decap_8
XFILLER_44_141 VGND VGND VPWR VPWR sky130_fd_sc_hd__decap_4
X_0970_ net74 net85 net87 net72 VGND VGND VPWR VPWR _0303_ sky130_fd_sc_hd__a22o_1
X_1453_ clknet_3_4__leaf_clk _0069_ VGND VGND VPWR VPWR core_out\[20\] sky130_fd_sc_hd__dfxtp_2
X_1384_ clknet_3_2__leaf_clk _0000_ VGND VGND VPWR VPWR core_valid sky130_fd_sc_hd__dfxtp_1
XFILLER_23_325 VGND VGND VPWR VPWR sky130_fd_sc_hd__decap_8
XFILLER_31_391 VGND VGND VPWR VPWR sky130_fd_sc_hd__fill_1
XFILLER_58_233 VPWR VGND VPWR VGND sky130_ef_sc_hd__decap_12
XFILLER_26_141 VPWR VGND VPWR VGND sky130_ef_sc_hd__decap_12
XFILLER_26_130 VGND VGND VPWR VPWR sky130_fd_sc_hd__decap_8
XFILLER_25_53 VGND VGND VPWR VPWR sky130_fd_sc_hd__decap_3
XFILLER_41_177 VGND VGND VPWR VPWR sky130_fd_sc_hd__decap_3
XFILLER_37_9 VGND VGND VPWR VPWR sky130_fd_sc_hd__fill_1
XFILLER_64_225 VGND VGND VPWR VPWR sky130_fd_sc_hd__fill_2
XFILLER_1_273 VGND VGND VPWR VPWR sky130_fd_sc_hd__decap_6
XTAP_TAPCELL_ROW_47_467 VGND VPWR sky130_fd_sc_hd__tapvpwrvgnd_1
XFILLER_32_155 VPWR VGND VPWR VGND sky130_ef_sc_hd__decap_12
XFILLER_17_163 VGND VGND VPWR VPWR sky130_fd_sc_hd__fill_1
X_0884_ core_out\[4\] _0219_ net96 VGND VGND VPWR VPWR _0220_ sky130_fd_sc_hd__mux2_1
X_0953_ _0284_ _0285_ core_out\[6\] VGND VGND VPWR VPWR _0287_ sky130_fd_sc_hd__a21o_1
XFILLER_9_373 VPWR VGND VPWR VGND sky130_ef_sc_hd__decap_12
XFILLER_13_391 VGND VGND VPWR VPWR sky130_fd_sc_hd__fill_1
X_1367_ net96 _0676_ _0677_ net9 VGND VGND VPWR VPWR _0078_ sky130_fd_sc_hd__a211oi_1
X_1436_ clknet_3_2__leaf_clk _0052_ VGND VGND VPWR VPWR core_out\[3\] sky130_fd_sc_hd__dfxtp_1
XFILLER_55_225 VPWR VGND VPWR VGND sky130_ef_sc_hd__decap_12
X_1298_ core_out\[20\] net54 VGND VGND VPWR VPWR _0618_ sky130_fd_sc_hd__xnor2_1
XFILLER_62_29 VPWR VGND VPWR VGND sky130_ef_sc_hd__decap_12
XFILLER_11_317 VPWR VGND VPWR VGND sky130_ef_sc_hd__decap_12
XFILLER_23_133 VGND VGND VPWR VPWR sky130_fd_sc_hd__decap_3
XFILLER_11_55 VGND VGND VPWR VPWR sky130_fd_sc_hd__fill_1
XTAP_TAPCELL_ROW_44_448 VGND VPWR sky130_fd_sc_hd__tapvpwrvgnd_1
XFILLER_36_96 VPWR VGND VPWR VGND sky130_ef_sc_hd__decap_12
XFILLER_36_85 VGND VGND VPWR VPWR sky130_fd_sc_hd__fill_1
XFILLER_36_41 VGND VGND VPWR VPWR sky130_fd_sc_hd__decap_3
XFILLER_14_133 VGND VGND VPWR VPWR sky130_fd_sc_hd__decap_6
XFILLER_6_321 VPWR VGND VPWR VGND sky130_ef_sc_hd__decap_12
XFILLER_6_365 VPWR VGND VPWR VGND sky130_ef_sc_hd__decap_12
Xinput16 wdata[5] VGND VGND VPWR VPWR net16 sky130_fd_sc_hd__buf_1
X_1221_ _0546_ _0547_ VGND VGND VPWR VPWR _0548_ sky130_fd_sc_hd__xor2_2
XFILLER_37_225 VPWR VGND VPWR VGND sky130_ef_sc_hd__decap_12
X_1083_ _0412_ _0413_ VGND VGND VPWR VPWR _0414_ sky130_fd_sc_hd__nand2_1
X_1152_ _0472_ _0480_ VGND VGND VPWR VPWR _0481_ sky130_fd_sc_hd__or2_1
X_0936_ _0267_ _0268_ _0269_ VGND VGND VPWR VPWR _0270_ sky130_fd_sc_hd__nand3_1
X_0867_ _0200_ _0201_ _0202_ VGND VGND VPWR VPWR _0203_ sky130_fd_sc_hd__or3_1
XFILLER_9_181 VPWR VGND VPWR VGND sky130_ef_sc_hd__decap_12
X_0798_ net109 _0145_ VGND VGND VPWR VPWR _0041_ sky130_fd_sc_hd__and2_1
X_1419_ clknet_3_6__leaf_clk _0035_ VGND VGND VPWR VPWR net38 sky130_fd_sc_hd__dfxtp_1
XFILLER_57_18 VPWR VGND VPWR VGND sky130_ef_sc_hd__decap_12
XFILLER_28_236 VPWR VGND VPWR VGND sky130_ef_sc_hd__decap_12
XFILLER_51_272 VGND VGND VPWR VPWR sky130_fd_sc_hd__fill_1
XTAP_TAPCELL_ROW_41_429 VGND VPWR sky130_fd_sc_hd__tapvpwrvgnd_1
XFILLER_36_280 VGND VGND VPWR VPWR sky130_fd_sc_hd__decap_4
XFILLER_28_269 VGND VGND VPWR VPWR sky130_fd_sc_hd__fill_1
XFILLER_11_169 VGND VGND VPWR VPWR sky130_fd_sc_hd__decap_4
XFILLER_22_76 VGND VGND VPWR VPWR sky130_fd_sc_hd__decap_8
XFILLER_3_335 VGND VGND VPWR VPWR sky130_fd_sc_hd__fill_1
XFILLER_0_3 VPWR VGND VPWR VGND sky130_ef_sc_hd__decap_12
XFILLER_59_361 VPWR VGND VPWR VGND sky130_ef_sc_hd__decap_12
XTAP_TAPCELL_ROW_57_540 VGND VPWR sky130_fd_sc_hd__tapvpwrvgnd_1
XTAP_TAPCELL_ROW_6_184 VGND VPWR sky130_fd_sc_hd__tapvpwrvgnd_1
XFILLER_19_225 VPWR VGND VPWR VGND sky130_ef_sc_hd__decap_12
XFILLER_6_195 VGND VGND VPWR VPWR sky130_fd_sc_hd__fill_1
X_0721_ net19 net10 VGND VGND VPWR VPWR _0101_ sky130_fd_sc_hd__and2b_4
XFILLER_33_3 VPWR VGND VPWR VGND sky130_ef_sc_hd__decap_12
X_1204_ _0398_ _0500_ VGND VGND VPWR VPWR _0531_ sky130_fd_sc_hd__and2_1
X_1135_ net99 core_out\[10\] net114 _0464_ VGND VGND VPWR VPWR _0059_ sky130_fd_sc_hd__o211a_1
X_1066_ net74 net83 _0353_ net128 VGND VGND VPWR VPWR _0397_ sky130_fd_sc_hd__a31o_1
XFILLER_25_217 VGND VGND VPWR VPWR sky130_fd_sc_hd__decap_6
X_0919_ _0221_ _0225_ net67 net95 VGND VGND VPWR VPWR _0253_ sky130_fd_sc_hd__o211a_1
XFILLER_0_349 VPWR VGND VPWR VGND sky130_ef_sc_hd__decap_12
XFILLER_0_305 VGND VGND VPWR VPWR sky130_fd_sc_hd__decap_3
XTAP_TAPCELL_ROW_54_521 VGND VPWR sky130_fd_sc_hd__tapvpwrvgnd_1
XFILLER_48_309 VGND VGND VPWR VPWR sky130_fd_sc_hd__fill_2
XFILLER_12_401 VGND VGND VPWR VPWR sky130_fd_sc_hd__decap_6
XFILLER_24_250 VGND VGND VPWR VPWR sky130_fd_sc_hd__fill_2
XFILLER_58_83 VGND VGND VPWR VPWR sky130_fd_sc_hd__fill_1
XFILLER_62_389 VPWR VGND VPWR VGND sky130_ef_sc_hd__decap_12
XTAP_TAPCELL_ROW_17_256 VGND VPWR sky130_fd_sc_hd__tapvpwrvgnd_1
XTAP_TAPCELL_ROW_60_557 VGND VPWR sky130_fd_sc_hd__tapvpwrvgnd_1
XFILLER_30_253 VGND VGND VPWR VPWR sky130_fd_sc_hd__fill_2
XPHY_EDGE_ROW_29_Left_94 VGND VGND VPWR VPWR sky130_fd_sc_hd__decap_3
X_0704_ net109 _0091_ VGND VGND VPWR VPWR _0001_ sky130_fd_sc_hd__and2_1
XTAP_TAPCELL_ROW_0_135 VGND VPWR sky130_fd_sc_hd__tapvpwrvgnd_1
XPHY_EDGE_ROW_13_Left_78 VGND VGND VPWR VPWR sky130_fd_sc_hd__decap_3
X_1049_ core_out\[8\] _0380_ net100 VGND VGND VPWR VPWR _0381_ sky130_fd_sc_hd__mux2_1
X_1118_ _0445_ _0446_ VGND VGND VPWR VPWR _0448_ sky130_fd_sc_hd__xnor2_1
XFILLER_0_90 VGND VGND VPWR VPWR sky130_fd_sc_hd__decap_8
XFILLER_0_113 VPWR VGND VPWR VGND sky130_ef_sc_hd__decap_12
XFILLER_56_194 VGND VGND VPWR VPWR sky130_fd_sc_hd__fill_2
XFILLER_28_97 VPWR VGND VPWR VGND sky130_ef_sc_hd__decap_12
XFILLER_28_53 VGND VGND VPWR VPWR sky130_fd_sc_hd__decap_8
XFILLER_12_253 VGND VGND VPWR VPWR sky130_fd_sc_hd__fill_1
XFILLER_12_297 VGND VGND VPWR VPWR sky130_fd_sc_hd__decap_8
XTAP_TAPCELL_ROW_14_237 VGND VPWR sky130_fd_sc_hd__tapvpwrvgnd_1
XTAP_TAPCELL_ROW_22_292 VGND VPWR sky130_fd_sc_hd__tapvpwrvgnd_1
XFILLER_5_57 VPWR VGND VPWR VGND sky130_ef_sc_hd__decap_12
XFILLER_54_109 VPWR VGND VPWR VGND sky130_ef_sc_hd__decap_12
XFILLER_62_153 VPWR VGND VPWR VGND sky130_ef_sc_hd__decap_12
XFILLER_50_304 VGND VGND VPWR VPWR sky130_fd_sc_hd__decap_4
XFILLER_35_389 VGND VGND VPWR VPWR sky130_fd_sc_hd__decap_3
XFILLER_35_378 VGND VGND VPWR VPWR sky130_fd_sc_hd__fill_2
XFILLER_41_304 VPWR VGND VPWR VGND sky130_ef_sc_hd__decap_12
XFILLER_26_301 VGND VGND VPWR VPWR sky130_fd_sc_hd__decap_6
XFILLER_41_337 VGND VGND VPWR VPWR sky130_fd_sc_hd__decap_3
XTAP_TAPCELL_ROW_36_395 VGND VPWR sky130_fd_sc_hd__tapvpwrvgnd_1
XTAP_TAPCELL_ROW_11_218 VGND VPWR sky130_fd_sc_hd__tapvpwrvgnd_1
XFILLER_5_249 VPWR VGND VPWR VGND sky130_ef_sc_hd__decap_12
XFILLER_5_205 VPWR VGND VPWR VGND sky130_ef_sc_hd__decap_12
XFILLER_44_197 VGND VGND VPWR VPWR sky130_fd_sc_hd__fill_1
XFILLER_44_131 VGND VGND VPWR VPWR sky130_fd_sc_hd__decap_8
XFILLER_32_304 VGND VGND VPWR VPWR sky130_fd_sc_hd__decap_4
X_1383_ _0689_ _0690_ _0691_ net9 VGND VGND VPWR VPWR _0080_ sky130_fd_sc_hd__a211oi_1
X_1452_ clknet_3_4__leaf_clk _0068_ VGND VGND VPWR VPWR core_out\[19\] sky130_fd_sc_hd__dfxtp_1
XFILLER_23_337 VPWR VGND VPWR VGND sky130_ef_sc_hd__decap_12
XFILLER_58_245 VGND VGND VPWR VPWR sky130_fd_sc_hd__decap_6
XPHY_EDGE_ROW_16_Left_81 VGND VGND VPWR VPWR sky130_fd_sc_hd__decap_3
XFILLER_26_197 VPWR VGND VPWR VGND sky130_ef_sc_hd__decap_12
XFILLER_26_175 VPWR VGND VPWR VGND sky130_ef_sc_hd__decap_12
XFILLER_26_153 VGND VGND VPWR VPWR sky130_fd_sc_hd__decap_8
XTAP_TAPCELL_ROW_24_310 VGND VPWR sky130_fd_sc_hd__tapvpwrvgnd_1
XFILLER_41_189 VPWR VGND VPWR VGND sky130_ef_sc_hd__decap_12
XFILLER_41_167 VGND VGND VPWR VPWR sky130_fd_sc_hd__fill_1
XFILLER_41_20 VGND VGND VPWR VPWR sky130_fd_sc_hd__decap_8
XFILLER_49_201 VGND VGND VPWR VPWR sky130_fd_sc_hd__fill_2
XFILLER_49_245 VGND VGND VPWR VPWR sky130_fd_sc_hd__fill_2
XTAP_TAPCELL_ROW_47_468 VGND VPWR sky130_fd_sc_hd__tapvpwrvgnd_1
X_0952_ core_out\[6\] _0284_ _0285_ VGND VGND VPWR VPWR _0286_ sky130_fd_sc_hd__and3_1
XFILLER_32_167 VGND VGND VPWR VPWR sky130_fd_sc_hd__decap_4
XFILLER_32_112 VPWR VGND VPWR VGND sky130_ef_sc_hd__decap_12
XFILLER_20_307 VGND VGND VPWR VPWR sky130_fd_sc_hd__fill_1
XFILLER_63_3 VPWR VGND VPWR VGND sky130_ef_sc_hd__decap_12
X_0883_ _0217_ _0218_ VGND VGND VPWR VPWR _0219_ sky130_fd_sc_hd__xnor2_1
XFILLER_9_385 VGND VGND VPWR VPWR sky130_fd_sc_hd__decap_6
X_1366_ net103 net183 VGND VGND VPWR VPWR _0677_ sky130_fd_sc_hd__nor2_1
X_1435_ clknet_3_2__leaf_clk _0051_ VGND VGND VPWR VPWR core_out\[2\] sky130_fd_sc_hd__dfxtp_1
XFILLER_63_281 VPWR VGND VPWR VGND sky130_ef_sc_hd__decap_12
XFILLER_55_237 VGND VGND VPWR VPWR sky130_fd_sc_hd__decap_8
X_1297_ net101 net178 net114 _0617_ VGND VGND VPWR VPWR _0068_ sky130_fd_sc_hd__o211a_1
XFILLER_11_329 VGND VGND VPWR VPWR sky130_fd_sc_hd__decap_6
XFILLER_46_259 VPWR VGND VPWR VGND sky130_ef_sc_hd__decap_12
XFILLER_52_85 VGND VGND VPWR VPWR sky130_fd_sc_hd__decap_8
XTAP_TAPCELL_ROW_44_449 VGND VPWR sky130_fd_sc_hd__tapvpwrvgnd_1
XPHY_EDGE_ROW_1_Left_66 VGND VGND VPWR VPWR sky130_fd_sc_hd__decap_3
Xinput17 wdata[6] VGND VGND VPWR VPWR net17 sky130_fd_sc_hd__clkbuf_1
XFILLER_6_333 VPWR VGND VPWR VGND sky130_ef_sc_hd__decap_12
XFILLER_6_377 VPWR VGND VPWR VGND sky130_ef_sc_hd__decap_12
X_1220_ _0467_ _0510_ _0509_ VGND VGND VPWR VPWR _0547_ sky130_fd_sc_hd__a21oi_2
X_1151_ _0477_ _0478_ VGND VGND VPWR VPWR _0480_ sky130_fd_sc_hd__xnor2_1
XFILLER_45_281 VPWR VGND VPWR VGND sky130_ef_sc_hd__decap_12
X_1082_ _0370_ _0368_ _0410_ _0411_ VGND VGND VPWR VPWR _0413_ sky130_fd_sc_hd__a211o_1
X_0866_ net131 net87 net89 net76 VGND VGND VPWR VPWR _0202_ sky130_fd_sc_hd__a22oi_2
X_0935_ _0227_ _0229_ _0228_ VGND VGND VPWR VPWR _0269_ sky130_fd_sc_hd__o21bai_1
XFILLER_9_160 VGND VGND VPWR VPWR sky130_fd_sc_hd__decap_8
XFILLER_9_193 VGND VGND VPWR VPWR sky130_fd_sc_hd__fill_2
X_0797_ net132 net11 _0144_ VGND VGND VPWR VPWR _0145_ sky130_fd_sc_hd__mux2_1
X_1418_ clknet_3_6__leaf_clk _0034_ VGND VGND VPWR VPWR net37 sky130_fd_sc_hd__dfxtp_1
X_1349_ _0660_ _0661_ VGND VGND VPWR VPWR _0662_ sky130_fd_sc_hd__xor2_1
XFILLER_28_248 VGND VGND VPWR VPWR sky130_fd_sc_hd__decap_4
XFILLER_11_126 VPWR VGND VPWR VGND sky130_ef_sc_hd__decap_12
XFILLER_59_373 VPWR VGND VPWR VGND sky130_ef_sc_hd__decap_12
XTAP_TAPCELL_ROW_6_185 VGND VPWR sky130_fd_sc_hd__tapvpwrvgnd_1
XFILLER_63_51 VGND VGND VPWR VPWR sky130_fd_sc_hd__decap_4
XTAP_TAPCELL_ROW_57_541 VGND VPWR sky130_fd_sc_hd__tapvpwrvgnd_1
XFILLER_47_96 VPWR VGND VPWR VGND sky130_ef_sc_hd__decap_12
XFILLER_27_281 VPWR VGND VPWR VGND sky130_ef_sc_hd__decap_12
XFILLER_19_237 VGND VGND VPWR VPWR sky130_fd_sc_hd__decap_8
X_0720_ _0088_ _0099_ VGND VGND VPWR VPWR _0100_ sky130_fd_sc_hd__nor2_4
XFILLER_6_141 VPWR VGND VPWR VGND sky130_ef_sc_hd__decap_12
X_1134_ net99 _0463_ VGND VGND VPWR VPWR _0464_ sky130_fd_sc_hd__nand2_1
X_1203_ net98 core_out\[12\] net116 _0530_ VGND VGND VPWR VPWR _0061_ sky130_fd_sc_hd__o211a_1
X_1065_ net129 _0352_ net74 net81 VGND VGND VPWR VPWR _0396_ sky130_fd_sc_hd__a2bb2o_1
X_0918_ net96 net175 net111 _0252_ VGND VGND VPWR VPWR _0054_ sky130_fd_sc_hd__o211a_1
X_0849_ net73 net94 _0184_ _0185_ VGND VGND VPWR VPWR _0186_ sky130_fd_sc_hd__nand4_1
XFILLER_56_365 VPWR VGND VPWR VGND sky130_ef_sc_hd__decap_12
XFILLER_17_66 VGND VGND VPWR VPWR sky130_fd_sc_hd__decap_6
XFILLER_17_88 VPWR VGND VPWR VGND sky130_ef_sc_hd__decap_12
XFILLER_33_32 VGND VGND VPWR VPWR sky130_fd_sc_hd__fill_2
XFILLER_3_111 VGND VGND VPWR VPWR sky130_fd_sc_hd__fill_1
XFILLER_59_192 VPWR VGND VPWR VGND sky130_ef_sc_hd__decap_12
XFILLER_30_221 VPWR VGND VPWR VGND sky130_ef_sc_hd__decap_12
XTAP_TAPCELL_ROW_17_257 VGND VPWR sky130_fd_sc_hd__tapvpwrvgnd_1
XTAP_TAPCELL_ROW_60_558 VGND VPWR sky130_fd_sc_hd__tapvpwrvgnd_1
X_0703_ net94 net11 _0090_ VGND VGND VPWR VPWR _0091_ sky130_fd_sc_hd__mux2_1
XFILLER_38_365 VGND VGND VPWR VPWR sky130_fd_sc_hd__fill_1
XFILLER_38_332 VGND VGND VPWR VPWR sky130_fd_sc_hd__decap_4
XTAP_TAPCELL_ROW_0_136 VGND VPWR sky130_fd_sc_hd__tapvpwrvgnd_1
X_1117_ _0446_ _0445_ VGND VGND VPWR VPWR _0447_ sky130_fd_sc_hd__nand2b_1
X_1048_ _0378_ _0379_ VGND VGND VPWR VPWR _0380_ sky130_fd_sc_hd__xnor2_1
XPHY_EDGE_ROW_3_Right_3 VGND VGND VPWR VPWR sky130_fd_sc_hd__decap_3
XFILLER_21_232 VPWR VGND VPWR VGND sky130_ef_sc_hd__decap_12
XFILLER_0_125 VPWR VGND VPWR VGND sky130_ef_sc_hd__decap_12
XFILLER_0_169 VPWR VGND VPWR VGND sky130_ef_sc_hd__decap_12
XFILLER_60_85 VPWR VGND VPWR VGND sky130_ef_sc_hd__decap_12
XFILLER_60_41 VPWR VGND VPWR VGND sky130_ef_sc_hd__decap_12
XPHY_EDGE_ROW_30_Left_95 VGND VGND VPWR VPWR sky130_fd_sc_hd__decap_3
XTAP_TAPCELL_ROW_14_238 VGND VPWR sky130_fd_sc_hd__tapvpwrvgnd_1
XTAP_TAPCELL_ROW_22_293 VGND VPWR sky130_fd_sc_hd__tapvpwrvgnd_1
XFILLER_5_69 VPWR VGND VPWR VGND sky130_ef_sc_hd__decap_12
XFILLER_62_121 VPWR VGND VPWR VGND sky130_ef_sc_hd__decap_12
XFILLER_39_118 VGND VGND VPWR VPWR sky130_fd_sc_hd__decap_8
XFILLER_62_165 VGND VGND VPWR VPWR sky130_fd_sc_hd__decap_8
XFILLER_41_316 VGND VGND VPWR VPWR sky130_fd_sc_hd__fill_1
XFILLER_38_195 VGND VGND VPWR VPWR sky130_fd_sc_hd__fill_1
XFILLER_5_217 VGND VGND VPWR VPWR sky130_fd_sc_hd__decap_6
XTAP_TAPCELL_ROW_11_219 VGND VPWR sky130_fd_sc_hd__tapvpwrvgnd_1
XFILLER_30_55 VGND VGND VPWR VPWR sky130_fd_sc_hd__decap_3
XFILLER_55_30 VPWR VGND VPWR VGND sky130_ef_sc_hd__decap_12
XFILLER_39_75 VGND VGND VPWR VPWR sky130_fd_sc_hd__fill_1
XFILLER_39_53 VGND VGND VPWR VPWR sky130_fd_sc_hd__decap_3
XFILLER_17_335 VGND VGND VPWR VPWR sky130_fd_sc_hd__fill_1
XTAP_TAPCELL_ROW_27_330 VGND VPWR sky130_fd_sc_hd__tapvpwrvgnd_1
X_1382_ net185 net96 VGND VGND VPWR VPWR _0691_ sky130_fd_sc_hd__nor2_1
X_1451_ clknet_3_4__leaf_clk _0067_ VGND VGND VPWR VPWR core_out\[18\] sky130_fd_sc_hd__dfxtp_1
XFILLER_31_393 VGND VGND VPWR VPWR sky130_fd_sc_hd__decap_3
XFILLER_23_349 VPWR VGND VPWR VGND sky130_ef_sc_hd__decap_12
XFILLER_2_209 VPWR VGND VPWR VGND sky130_ef_sc_hd__decap_12
XFILLER_26_187 VGND VGND VPWR VPWR sky130_fd_sc_hd__decap_8
XFILLER_26_165 VGND VGND VPWR VPWR sky130_fd_sc_hd__decap_4
XTAP_TAPCELL_ROW_24_311 VGND VPWR sky130_fd_sc_hd__tapvpwrvgnd_1
XFILLER_41_54 VGND VGND VPWR VPWR sky130_fd_sc_hd__fill_2
XFILLER_2_15 VPWR VGND VPWR VGND sky130_ef_sc_hd__decap_12
XFILLER_64_238 VPWR VGND VPWR VGND sky130_ef_sc_hd__decap_12
XTAP_TAPCELL_ROW_47_469 VGND VPWR sky130_fd_sc_hd__tapvpwrvgnd_1
X_0951_ _0245_ _0282_ _0283_ VGND VGND VPWR VPWR _0285_ sky130_fd_sc_hd__nand3_1
X_0882_ _0192_ _0194_ _0191_ VGND VGND VPWR VPWR _0218_ sky130_fd_sc_hd__a21bo_1
XFILLER_32_124 VPWR VGND VPWR VGND sky130_ef_sc_hd__decap_12
XTAP_TAPCELL_ROW_30_347 VGND VPWR sky130_fd_sc_hd__tapvpwrvgnd_1
XFILLER_13_393 VPWR VGND VPWR VGND sky130_ef_sc_hd__decap_12
XFILLER_55_249 VPWR VGND VPWR VGND sky130_ef_sc_hd__decap_12
X_1365_ _0674_ _0675_ VGND VGND VPWR VPWR _0676_ sky130_fd_sc_hd__xor2_1
X_1296_ net101 _0616_ VGND VGND VPWR VPWR _0617_ sky130_fd_sc_hd__nand2_1
XTAP_TAPCELL_ROW_38_403 VGND VPWR sky130_fd_sc_hd__tapvpwrvgnd_1
X_1434_ clknet_3_0__leaf_clk _0050_ VGND VGND VPWR VPWR core_out\[1\] sky130_fd_sc_hd__dfxtp_1
XFILLER_63_293 VPWR VGND VPWR VGND sky130_ef_sc_hd__decap_12
XFILLER_11_24 VGND VGND VPWR VPWR sky130_fd_sc_hd__fill_1
XFILLER_11_57 VPWR VGND VPWR VGND sky130_ef_sc_hd__decap_12
XFILLER_46_249 VGND VGND VPWR VPWR sky130_fd_sc_hd__decap_3
XFILLER_36_54 VPWR VGND VPWR VGND sky130_ef_sc_hd__decap_12
Xinput18 wdata[7] VGND VGND VPWR VPWR net18 sky130_fd_sc_hd__clkbuf_1
XFILLER_6_301 VGND VGND VPWR VPWR sky130_fd_sc_hd__decap_6
XFILLER_42_9 VGND VGND VPWR VPWR sky130_fd_sc_hd__fill_1
XFILLER_6_345 VPWR VGND VPWR VGND sky130_ef_sc_hd__decap_12
XFILLER_6_389 VPWR VGND VPWR VGND sky130_ef_sc_hd__decap_12
XFILLER_10_363 VGND VGND VPWR VPWR sky130_fd_sc_hd__fill_1
X_1150_ _0477_ _0478_ VGND VGND VPWR VPWR _0479_ sky130_fd_sc_hd__nand2_1
XFILLER_45_293 VPWR VGND VPWR VGND sky130_ef_sc_hd__decap_12
X_1081_ _0410_ _0411_ _0368_ _0370_ VGND VGND VPWR VPWR _0412_ sky130_fd_sc_hd__o211ai_2
X_0865_ net76 net126 net87 net89 VGND VGND VPWR VPWR _0201_ sky130_fd_sc_hd__and4_1
X_0934_ net125 _0265_ _0262_ VGND VGND VPWR VPWR _0268_ sky130_fd_sc_hd__o21ai_1
X_1417_ clknet_3_4__leaf_clk _0033_ VGND VGND VPWR VPWR net36 sky130_fd_sc_hd__dfxtp_1
X_0796_ net10 net19 _0100_ VGND VGND VPWR VPWR _0144_ sky130_fd_sc_hd__and3_4
X_1348_ _0655_ _0657_ _0654_ VGND VGND VPWR VPWR _0661_ sky130_fd_sc_hd__o21ai_2
X_1279_ _0601_ _0602_ net99 VGND VGND VPWR VPWR _0603_ sky130_fd_sc_hd__a21bo_1
XFILLER_28_227 VGND VGND VPWR VPWR sky130_fd_sc_hd__fill_1
XFILLER_11_138 VGND VGND VPWR VPWR sky130_fd_sc_hd__decap_4
XFILLER_11_149 VGND VGND VPWR VPWR sky130_fd_sc_hd__decap_6
XFILLER_3_337 VPWR VGND VPWR VGND sky130_ef_sc_hd__decap_12
XFILLER_59_385 VGND VGND VPWR VPWR sky130_fd_sc_hd__decap_6
XTAP_TAPCELL_ROW_57_542 VGND VPWR sky130_fd_sc_hd__tapvpwrvgnd_1
XFILLER_42_241 VGND VGND VPWR VPWR sky130_fd_sc_hd__fill_1
XFILLER_27_293 VGND VGND VPWR VPWR sky130_fd_sc_hd__decap_8
XFILLER_42_285 VGND VGND VPWR VPWR sky130_fd_sc_hd__fill_1
XTAP_TAPCELL_ROW_40_420 VGND VPWR sky130_fd_sc_hd__tapvpwrvgnd_1
XFILLER_6_153 VPWR VGND VPWR VGND sky130_ef_sc_hd__decap_12
X_1133_ _0460_ _0461_ VGND VGND VPWR VPWR _0463_ sky130_fd_sc_hd__xnor2_1
X_1064_ _0351_ _0352_ net74 VGND VGND VPWR VPWR _0395_ sky130_fd_sc_hd__or3b_1
X_1202_ net98 _0529_ VGND VGND VPWR VPWR _0530_ sky130_fd_sc_hd__nand2_1
XTAP_TAPCELL_ROW_63_578 VGND VPWR sky130_fd_sc_hd__tapvpwrvgnd_1
X_0779_ net147 _0101_ net58 _0135_ net114 VGND VGND VPWR VPWR _0032_ sky130_fd_sc_hd__o221a_1
X_0917_ net97 _0251_ VGND VGND VPWR VPWR _0252_ sky130_fd_sc_hd__nand2_1
X_0848_ _0181_ _0182_ _0183_ VGND VGND VPWR VPWR _0185_ sky130_fd_sc_hd__a21o_1
XFILLER_56_377 VPWR VGND VPWR VGND sky130_ef_sc_hd__decap_12
XFILLER_56_333 VGND VGND VPWR VPWR sky130_fd_sc_hd__fill_1
XFILLER_24_230 VPWR VGND VPWR VGND sky130_ef_sc_hd__decap_12
XFILLER_3_167 VGND VGND VPWR VPWR sky130_fd_sc_hd__fill_1
XFILLER_58_85 VPWR VGND VPWR VGND sky130_ef_sc_hd__decap_12
XFILLER_58_41 VPWR VGND VPWR VGND sky130_ef_sc_hd__decap_12
XFILLER_47_333 VGND VGND VPWR VPWR sky130_fd_sc_hd__decap_3
XFILLER_62_325 VPWR VGND VPWR VGND sky130_ef_sc_hd__decap_12
XTAP_TAPCELL_ROW_60_559 VGND VPWR sky130_fd_sc_hd__tapvpwrvgnd_1
XFILLER_30_233 VPWR VGND VPWR VGND sky130_ef_sc_hd__decap_12
XTAP_TAPCELL_ROW_17_258 VGND VPWR sky130_fd_sc_hd__tapvpwrvgnd_1
X_0702_ net10 net19 net64 VGND VGND VPWR VPWR _0090_ sky130_fd_sc_hd__and3_4
X_1047_ _0331_ _0332_ _0330_ VGND VGND VPWR VPWR _0379_ sky130_fd_sc_hd__o21bai_2
XFILLER_0_81 VGND VGND VPWR VPWR sky130_fd_sc_hd__decap_3
XTAP_TAPCELL_ROW_0_137 VGND VPWR sky130_fd_sc_hd__tapvpwrvgnd_1
X_1116_ _0389_ _0405_ _0404_ VGND VGND VPWR VPWR _0446_ sky130_fd_sc_hd__a21boi_1
XFILLER_61_391 VGND VGND VPWR VPWR sky130_fd_sc_hd__fill_1
XFILLER_21_244 VPWR VGND VPWR VGND sky130_ef_sc_hd__decap_12
XFILLER_0_104 VGND VGND VPWR VPWR sky130_fd_sc_hd__decap_8
XFILLER_56_141 VPWR VGND VPWR VGND sky130_ef_sc_hd__decap_12
XFILLER_48_119 VGND VGND VPWR VPWR sky130_fd_sc_hd__fill_1
XFILLER_29_300 VPWR VGND VPWR VGND sky130_ef_sc_hd__decap_12
XFILLER_0_137 VGND VGND VPWR VPWR sky130_fd_sc_hd__decap_3
XFILLER_56_185 VGND VGND VPWR VPWR sky130_fd_sc_hd__fill_2
XFILLER_52_380 VPWR VGND VPWR VGND sky130_ef_sc_hd__decap_12
XTAP_TAPCELL_ROW_14_239 VGND VPWR sky130_fd_sc_hd__tapvpwrvgnd_1
XFILLER_60_97 VGND VGND VPWR VPWR sky130_fd_sc_hd__decap_4
XFILLER_60_53 VPWR VGND VPWR VGND sky130_ef_sc_hd__decap_12
XFILLER_5_15 VPWR VGND VPWR VGND sky130_ef_sc_hd__decap_12
XTAP_TAPCELL_ROW_22_294 VGND VPWR sky130_fd_sc_hd__tapvpwrvgnd_1
XFILLER_62_133 VGND VGND VPWR VPWR sky130_fd_sc_hd__decap_6
XPHY_EDGE_ROW_13_Right_13 VGND VGND VPWR VPWR sky130_fd_sc_hd__decap_3
XFILLER_43_391 VGND VGND VPWR VPWR sky130_fd_sc_hd__fill_1
XPHY_EDGE_ROW_22_Right_22 VGND VGND VPWR VPWR sky130_fd_sc_hd__decap_3
XFILLER_7_281 VPWR VGND VPWR VGND sky130_ef_sc_hd__decap_12
XFILLER_38_141 VPWR VGND VPWR VGND sky130_ef_sc_hd__decap_12
XPHY_EDGE_ROW_31_Right_31 VGND VGND VPWR VPWR sky130_fd_sc_hd__decap_3
XPHY_EDGE_ROW_40_Right_40 VGND VGND VPWR VPWR sky130_fd_sc_hd__decap_3
XFILLER_39_21 VPWR VGND VPWR VGND sky130_ef_sc_hd__decap_12
XFILLER_55_42 VPWR VGND VPWR VGND sky130_ef_sc_hd__decap_12
XFILLER_29_141 VPWR VGND VPWR VGND sky130_ef_sc_hd__decap_12
XTAP_TAPCELL_ROW_27_331 VGND VPWR sky130_fd_sc_hd__tapvpwrvgnd_1
XFILLER_32_328 VGND VGND VPWR VPWR sky130_fd_sc_hd__decap_4
XFILLER_32_317 VGND VGND VPWR VPWR sky130_fd_sc_hd__decap_4
X_1450_ clknet_3_7__leaf_clk _0066_ VGND VGND VPWR VPWR core_out\[17\] sky130_fd_sc_hd__dfxtp_1
XFILLER_4_251 VGND VGND VPWR VPWR sky130_fd_sc_hd__fill_1
X_1381_ _0679_ _0684_ _0688_ net97 VGND VGND VPWR VPWR _0690_ sky130_fd_sc_hd__o31a_1
XFILLER_35_111 VGND VGND VPWR VPWR sky130_fd_sc_hd__fill_1
XFILLER_41_169 VGND VGND VPWR VPWR sky130_fd_sc_hd__decap_8
XFILLER_41_11 VGND VGND VPWR VPWR sky130_fd_sc_hd__fill_1
XFILLER_25_45 VGND VGND VPWR VPWR sky130_fd_sc_hd__decap_8
XFILLER_49_258 VPWR VGND VPWR VGND sky130_ef_sc_hd__decap_12
XFILLER_49_236 VGND VGND VPWR VPWR sky130_fd_sc_hd__fill_1
XFILLER_49_225 VGND VGND VPWR VPWR sky130_fd_sc_hd__fill_2
XFILLER_2_27 VGND VGND VPWR VPWR sky130_fd_sc_hd__fill_1
XFILLER_64_217 VGND VGND VPWR VPWR sky130_fd_sc_hd__decap_6
XFILLER_60_401 VGND VGND VPWR VPWR sky130_fd_sc_hd__decap_6
XFILLER_32_136 VGND VGND VPWR VPWR sky130_fd_sc_hd__decap_4
XFILLER_17_100 VPWR VGND VPWR VGND sky130_ef_sc_hd__decap_12
X_0881_ _0215_ _0216_ VGND VGND VPWR VPWR _0217_ sky130_fd_sc_hd__nand2b_1
X_0950_ _0282_ _0283_ _0245_ VGND VGND VPWR VPWR _0284_ sky130_fd_sc_hd__a21o_1
XTAP_TAPCELL_ROW_30_348 VGND VPWR sky130_fd_sc_hd__tapvpwrvgnd_1
XFILLER_13_361 VPWR VGND VPWR VGND sky130_ef_sc_hd__decap_12
XFILLER_20_309 VPWR VGND VPWR VGND sky130_ef_sc_hd__decap_12
X_1433_ clknet_3_0__leaf_clk _0049_ VGND VGND VPWR VPWR core_out\[0\] sky130_fd_sc_hd__dfxtp_1
XFILLER_55_206 VGND VGND VPWR VPWR sky130_fd_sc_hd__fill_1
X_1364_ _0667_ _0670_ _0668_ VGND VGND VPWR VPWR _0675_ sky130_fd_sc_hd__o21ba_1
X_1295_ _0614_ _0615_ VGND VGND VPWR VPWR _0616_ sky130_fd_sc_hd__xnor2_1
XTAP_TAPCELL_ROW_38_404 VGND VPWR sky130_fd_sc_hd__tapvpwrvgnd_1
XFILLER_23_103 VGND VGND VPWR VPWR sky130_fd_sc_hd__fill_1
XFILLER_23_125 VGND VGND VPWR VPWR sky130_fd_sc_hd__decap_8
XFILLER_23_169 VGND VGND VPWR VPWR sky130_fd_sc_hd__decap_4
XFILLER_11_47 VGND VGND VPWR VPWR sky130_fd_sc_hd__decap_8
XFILLER_11_69 VGND VGND VPWR VPWR sky130_fd_sc_hd__fill_1
XFILLER_46_217 VPWR VGND VPWR VGND sky130_ef_sc_hd__decap_12
XFILLER_36_66 VGND VGND VPWR VPWR sky130_fd_sc_hd__decap_8
XFILLER_14_169 VPWR VGND VPWR VGND sky130_ef_sc_hd__decap_12
Xinput19 write VGND VGND VPWR VPWR net19 sky130_fd_sc_hd__buf_1
XFILLER_6_357 VGND VGND VPWR VPWR sky130_fd_sc_hd__decap_6
X_1080_ _0408_ _0409_ _0342_ _0344_ VGND VGND VPWR VPWR _0411_ sky130_fd_sc_hd__o211a_1
XFILLER_60_297 VGND VGND VPWR VPWR sky130_fd_sc_hd__decap_3
XFILLER_60_253 VPWR VGND VPWR VGND sky130_ef_sc_hd__decap_12
XTAP_TAPCELL_ROW_43_440 VGND VPWR sky130_fd_sc_hd__tapvpwrvgnd_1
X_0795_ net159 net107 net59 _0143_ net110 VGND VGND VPWR VPWR _0040_ sky130_fd_sc_hd__o221a_1
X_0864_ net75 net91 VGND VGND VPWR VPWR _0200_ sky130_fd_sc_hd__nand2_1
X_0933_ _0262_ _0264_ _0265_ VGND VGND VPWR VPWR _0267_ sky130_fd_sc_hd__or3_1
X_1416_ clknet_3_7__leaf_clk _0032_ VGND VGND VPWR VPWR net35 sky130_fd_sc_hd__dfxtp_1
X_1347_ core_out\[27\] net52 VGND VGND VPWR VPWR _0660_ sky130_fd_sc_hd__xnor2_1
XFILLER_3_81 VPWR VGND VPWR VGND sky130_ef_sc_hd__decap_12
X_1278_ _0597_ _0600_ VGND VGND VPWR VPWR _0602_ sky130_fd_sc_hd__nand2_1
XFILLER_24_401 VGND VGND VPWR VPWR sky130_fd_sc_hd__decap_6
XFILLER_11_106 VGND VGND VPWR VPWR sky130_fd_sc_hd__decap_6
XFILLER_3_349 VPWR VGND VPWR VGND sky130_ef_sc_hd__decap_12
XFILLER_3_305 VPWR VGND VPWR VGND sky130_ef_sc_hd__decap_12
XFILLER_19_206 VPWR VGND VPWR VGND sky130_ef_sc_hd__decap_12
XFILLER_42_253 VPWR VGND VPWR VGND sky130_ef_sc_hd__decap_12
XFILLER_34_209 VPWR VGND VPWR VGND sky130_ef_sc_hd__decap_12
XFILLER_30_404 VGND VGND VPWR VPWR sky130_fd_sc_hd__decap_3
XFILLER_27_261 VGND VGND VPWR VPWR sky130_fd_sc_hd__decap_6
XFILLER_8_15 VPWR VGND VPWR VGND sky130_ef_sc_hd__decap_12
XTAP_TAPCELL_ROW_40_421 VGND VPWR sky130_fd_sc_hd__tapvpwrvgnd_1
XFILLER_6_165 VPWR VGND VPWR VGND sky130_ef_sc_hd__decap_12
XFILLER_6_121 VPWR VGND VPWR VGND sky130_ef_sc_hd__decap_12
X_1201_ _0497_ _0528_ VGND VGND VPWR VPWR _0529_ sky130_fd_sc_hd__xnor2_1
X_1132_ _0382_ _0417_ _0419_ _0460_ VGND VGND VPWR VPWR _0462_ sky130_fd_sc_hd__a211o_1
X_1063_ _0390_ _0393_ VGND VGND VPWR VPWR _0394_ sky130_fd_sc_hd__xnor2_1
XTAP_TAPCELL_ROW_63_579 VGND VPWR sky130_fd_sc_hd__tapvpwrvgnd_1
X_0916_ _0249_ _0250_ VGND VGND VPWR VPWR _0251_ sky130_fd_sc_hd__xor2_1
XFILLER_33_253 VGND VGND VPWR VPWR sky130_fd_sc_hd__fill_1
X_0778_ core_out\[23\] _0103_ VGND VGND VPWR VPWR _0135_ sky130_fd_sc_hd__and2_1
X_0847_ _0181_ _0182_ _0183_ VGND VGND VPWR VPWR _0184_ sky130_fd_sc_hd__nand3_1
XFILLER_56_301 VGND VGND VPWR VPWR sky130_fd_sc_hd__decap_6
XFILLER_56_389 VPWR VGND VPWR VGND sky130_ef_sc_hd__decap_12
XFILLER_16_209 VPWR VGND VPWR VGND sky130_ef_sc_hd__decap_12
XFILLER_24_242 VGND VGND VPWR VPWR sky130_fd_sc_hd__decap_8
XFILLER_24_253 VPWR VGND VPWR VGND sky130_ef_sc_hd__decap_12
XFILLER_33_45 VGND VGND VPWR VPWR sky130_fd_sc_hd__decap_4
XFILLER_58_53 VPWR VGND VPWR VGND sky130_ef_sc_hd__decap_12
XFILLER_3_113 VPWR VGND VPWR VGND sky130_ef_sc_hd__decap_12
XFILLER_62_337 VPWR VGND VPWR VGND sky130_ef_sc_hd__decap_12
XFILLER_58_97 VGND VGND VPWR VPWR sky130_fd_sc_hd__fill_2
XFILLER_47_301 VGND VGND VPWR VPWR sky130_fd_sc_hd__decap_8
XFILLER_30_245 VGND VGND VPWR VPWR sky130_fd_sc_hd__decap_6
XTAP_TAPCELL_ROW_17_259 VGND VPWR sky130_fd_sc_hd__tapvpwrvgnd_1
X_0701_ net2 net1 net3 _0088_ VGND VGND VPWR VPWR _0089_ sky130_fd_sc_hd__nor4_1
XFILLER_53_337 VPWR VGND VPWR VGND sky130_ef_sc_hd__decap_12
X_1046_ _0376_ _0377_ VGND VGND VPWR VPWR _0378_ sky130_fd_sc_hd__nand2b_1
XTAP_TAPCELL_ROW_0_138 VGND VPWR sky130_fd_sc_hd__tapvpwrvgnd_1
X_1115_ _0430_ _0444_ VGND VGND VPWR VPWR _0445_ sky130_fd_sc_hd__xnor2_1
XFILLER_21_223 VGND VGND VPWR VPWR sky130_fd_sc_hd__fill_1
XFILLER_21_256 VPWR VGND VPWR VGND sky130_ef_sc_hd__decap_12
XFILLER_56_197 VPWR VGND VPWR VGND sky130_ef_sc_hd__decap_12
XFILLER_56_153 VPWR VGND VPWR VGND sky130_ef_sc_hd__decap_12
XFILLER_29_323 VPWR VGND VPWR VGND sky130_ef_sc_hd__decap_12
XFILLER_29_312 VGND VGND VPWR VPWR sky130_fd_sc_hd__decap_8
XFILLER_52_392 VGND VGND VPWR VPWR sky130_fd_sc_hd__decap_6
XFILLER_8_216 VGND VGND VPWR VPWR sky130_fd_sc_hd__fill_1
XFILLER_12_212 VPWR VGND VPWR VGND sky130_ef_sc_hd__decap_12
XFILLER_60_65 VPWR VGND VPWR VGND sky130_ef_sc_hd__decap_12
XFILLER_5_27 VPWR VGND VPWR VGND sky130_ef_sc_hd__decap_12
XTAP_TAPCELL_ROW_22_295 VGND VPWR sky130_fd_sc_hd__tapvpwrvgnd_1
XFILLER_7_271 VGND VGND VPWR VPWR sky130_fd_sc_hd__decap_8
XFILLER_7_293 VPWR VGND VPWR VGND sky130_ef_sc_hd__decap_12
XFILLER_38_197 VGND VGND VPWR VPWR sky130_fd_sc_hd__decap_4
XFILLER_38_153 VPWR VGND VPWR VGND sky130_ef_sc_hd__decap_12
XFILLER_26_315 VPWR VGND VPWR VGND sky130_ef_sc_hd__decap_12
XFILLER_53_167 VGND VGND VPWR VPWR sky130_fd_sc_hd__fill_1
X_1029_ _0311_ _0305_ _0310_ VGND VGND VPWR VPWR _0361_ sky130_fd_sc_hd__a21bo_1
XFILLER_14_47 VGND VGND VPWR VPWR sky130_fd_sc_hd__fill_1
XFILLER_14_69 VPWR VGND VPWR VGND sky130_ef_sc_hd__decap_12
XFILLER_39_99 VGND VGND VPWR VPWR sky130_fd_sc_hd__decap_3
XFILLER_39_33 VPWR VGND VPWR VGND sky130_ef_sc_hd__decap_12
XFILLER_55_54 VGND VGND VPWR VPWR sky130_fd_sc_hd__fill_2
XFILLER_29_153 VGND VGND VPWR VPWR sky130_fd_sc_hd__decap_3
XTAP_TAPCELL_ROW_27_332 VGND VPWR sky130_fd_sc_hd__tapvpwrvgnd_1
XFILLER_17_337 VPWR VGND VPWR VGND sky130_ef_sc_hd__decap_12
XFILLER_40_384 VGND VGND VPWR VPWR sky130_fd_sc_hd__decap_4
XFILLER_40_373 VGND VGND VPWR VPWR sky130_fd_sc_hd__decap_3
XFILLER_40_340 VPWR VGND VPWR VGND sky130_ef_sc_hd__decap_12
XTAP_TAPCELL_ROW_10_210 VGND VPWR sky130_fd_sc_hd__tapvpwrvgnd_1
X_1380_ _0679_ _0684_ _0688_ VGND VGND VPWR VPWR _0689_ sky130_fd_sc_hd__o21ai_1
XFILLER_50_126 VPWR VGND VPWR VGND sky130_ef_sc_hd__decap_12
XFILLER_35_167 VGND VGND VPWR VPWR sky130_fd_sc_hd__fill_1
XFILLER_35_123 VPWR VGND VPWR VGND sky130_ef_sc_hd__decap_12
XTAP_TAPCELL_ROW_33_368 VGND VPWR sky130_fd_sc_hd__tapvpwrvgnd_1
XFILLER_23_318 VGND VGND VPWR VPWR sky130_fd_sc_hd__fill_2
XFILLER_14_307 VGND VGND VPWR VPWR sky130_fd_sc_hd__fill_1
XFILLER_25_57 VGND VGND VPWR VPWR sky130_fd_sc_hd__fill_1
XFILLER_25_79 VGND VGND VPWR VPWR sky130_fd_sc_hd__decap_3
XFILLER_9_3 VPWR VGND VPWR VGND sky130_ef_sc_hd__decap_12
XFILLER_57_281 VPWR VGND VPWR VGND sky130_ef_sc_hd__decap_12
XFILLER_17_167 VGND VGND VPWR VPWR sky130_fd_sc_hd__fill_1
X_0880_ _0213_ _0214_ core_out\[4\] VGND VGND VPWR VPWR _0216_ sky130_fd_sc_hd__a21o_1
XTAP_TAPCELL_ROW_30_349 VGND VPWR sky130_fd_sc_hd__tapvpwrvgnd_1
XFILLER_13_373 VPWR VGND VPWR VGND sky130_ef_sc_hd__decap_12
X_1363_ core_out\[29\] net52 VGND VGND VPWR VPWR _0674_ sky130_fd_sc_hd__xor2_1
X_1432_ clknet_3_1__leaf_clk _0048_ VGND VGND VPWR VPWR core_b\[7\] sky130_fd_sc_hd__dfxtp_2
XFILLER_51_402 VGND VGND VPWR VPWR sky130_fd_sc_hd__fill_1
XTAP_TAPCELL_ROW_46_460 VGND VPWR sky130_fd_sc_hd__tapvpwrvgnd_1
X_1294_ _0609_ _0611_ _0608_ VGND VGND VPWR VPWR _0615_ sky130_fd_sc_hd__o21a_1
XPHY_EDGE_ROW_43_Left_108 VGND VGND VPWR VPWR sky130_fd_sc_hd__decap_3
XTAP_TAPCELL_ROW_38_405 VGND VPWR sky130_fd_sc_hd__tapvpwrvgnd_1
XFILLER_31_181 VPWR VGND VPWR VGND sky130_ef_sc_hd__decap_12
XPHY_EDGE_ROW_52_Left_117 VGND VGND VPWR VPWR sky130_fd_sc_hd__decap_3
XFILLER_46_229 VPWR VGND VPWR VGND sky130_ef_sc_hd__decap_12
XPHY_EDGE_ROW_61_Left_126 VGND VGND VPWR VPWR sky130_fd_sc_hd__decap_3
XFILLER_42_402 VGND VGND VPWR VPWR sky130_fd_sc_hd__fill_1
XFILLER_10_321 VPWR VGND VPWR VGND sky130_ef_sc_hd__decap_12
XFILLER_10_365 VPWR VGND VPWR VGND sky130_ef_sc_hd__decap_12
XFILLER_45_262 VPWR VGND VPWR VGND sky130_ef_sc_hd__decap_12
XFILLER_37_207 VPWR VGND VPWR VGND sky130_ef_sc_hd__decap_12
XFILLER_60_265 VPWR VGND VPWR VGND sky130_ef_sc_hd__decap_12
XTAP_TAPCELL_ROW_43_441 VGND VPWR sky130_fd_sc_hd__tapvpwrvgnd_1
X_0932_ _0262_ _0264_ _0265_ VGND VGND VPWR VPWR _0266_ sky130_fd_sc_hd__nor3_1
XFILLER_13_181 VPWR VGND VPWR VGND sky130_ef_sc_hd__decap_12
XFILLER_61_3 VPWR VGND VPWR VGND sky130_ef_sc_hd__decap_12
X_0794_ core_out\[31\] net62 VGND VGND VPWR VPWR _0143_ sky130_fd_sc_hd__and2_1
X_0863_ _0197_ _0198_ VGND VGND VPWR VPWR _0199_ sky130_fd_sc_hd__nor2_1
XFILLER_5_391 VGND VGND VPWR VPWR sky130_fd_sc_hd__fill_1
X_1346_ net100 net174 net112 _0659_ VGND VGND VPWR VPWR _0075_ sky130_fd_sc_hd__o211a_1
X_1415_ clknet_3_7__leaf_clk _0031_ VGND VGND VPWR VPWR net34 sky130_fd_sc_hd__dfxtp_1
XFILLER_3_93 VPWR VGND VPWR VGND sky130_ef_sc_hd__decap_12
X_1277_ _0597_ _0600_ VGND VGND VPWR VPWR _0601_ sky130_fd_sc_hd__or2_4
XFILLER_36_240 VPWR VGND VPWR VGND sky130_ef_sc_hd__decap_12
XFILLER_51_298 VGND VGND VPWR VPWR sky130_fd_sc_hd__fill_1
XFILLER_59_310 VPWR VGND VPWR VGND sky130_ef_sc_hd__decap_12
XFILLER_3_317 VPWR VGND VPWR VGND sky130_ef_sc_hd__decap_12
XFILLER_47_55 VGND VGND VPWR VPWR sky130_fd_sc_hd__fill_1
XFILLER_19_218 VGND VGND VPWR VPWR sky130_fd_sc_hd__decap_6
XFILLER_42_265 VPWR VGND VPWR VGND sky130_ef_sc_hd__decap_12
XFILLER_42_221 VPWR VGND VPWR VGND sky130_ef_sc_hd__decap_12
XTAP_TAPCELL_ROW_40_422 VGND VPWR sky130_fd_sc_hd__tapvpwrvgnd_1
XFILLER_27_273 VGND VGND VPWR VPWR sky130_fd_sc_hd__decap_6
XFILLER_8_27 VGND VGND VPWR VPWR sky130_fd_sc_hd__fill_1
XFILLER_6_177 VGND VGND VPWR VPWR sky130_fd_sc_hd__decap_4
XFILLER_6_133 VGND VGND VPWR VPWR sky130_fd_sc_hd__decap_6
X_1200_ _0526_ core_out\[12\] VGND VGND VPWR VPWR _0528_ sky130_fd_sc_hd__xnor2_2
X_1131_ _0382_ _0417_ _0419_ VGND VGND VPWR VPWR _0461_ sky130_fd_sc_hd__a21o_1
XFILLER_33_221 VGND VGND VPWR VPWR sky130_fd_sc_hd__decap_3
X_1062_ _0391_ _0392_ VGND VGND VPWR VPWR _0393_ sky130_fd_sc_hd__and2b_1
XFILLER_18_251 VGND VGND VPWR VPWR sky130_fd_sc_hd__fill_1
X_0915_ _0216_ _0218_ _0215_ VGND VGND VPWR VPWR _0250_ sky130_fd_sc_hd__a21o_1
XFILLER_21_405 VGND VGND VPWR VPWR sky130_fd_sc_hd__fill_2
X_0777_ net144 _0101_ net58 _0134_ net114 VGND VGND VPWR VPWR _0031_ sky130_fd_sc_hd__o221a_1
X_0846_ _0164_ _0166_ _0165_ VGND VGND VPWR VPWR _0183_ sky130_fd_sc_hd__o21bai_1
XFILLER_0_309 VPWR VGND VPWR VGND sky130_ef_sc_hd__decap_12
XFILLER_56_313 VGND VGND VPWR VPWR sky130_fd_sc_hd__fill_1
X_1329_ _0622_ _0620_ _0644_ VGND VGND VPWR VPWR _0645_ sky130_fd_sc_hd__a21o_1
XTAP_TAPCELL_ROW_3_158 VGND VPWR sky130_fd_sc_hd__tapvpwrvgnd_1
XFILLER_24_265 VGND VGND VPWR VPWR sky130_fd_sc_hd__decap_4
XFILLER_3_125 VPWR VGND VPWR VGND sky130_ef_sc_hd__decap_12
XFILLER_58_65 VPWR VGND VPWR VGND sky130_ef_sc_hd__decap_12
XFILLER_47_313 VPWR VGND VPWR VGND sky130_ef_sc_hd__decap_12
XFILLER_3_169 VPWR VGND VPWR VGND sky130_ef_sc_hd__decap_12
XFILLER_62_349 VPWR VGND VPWR VGND sky130_ef_sc_hd__decap_12
X_0700_ net4 _0086_ VGND VGND VPWR VPWR _0088_ sky130_fd_sc_hd__or2_1
XFILLER_15_254 VPWR VGND VPWR VGND sky130_ef_sc_hd__decap_12
XFILLER_38_379 VGND VGND VPWR VPWR sky130_fd_sc_hd__decap_3
X_1114_ _0440_ _0441_ VGND VGND VPWR VPWR _0444_ sky130_fd_sc_hd__xnor2_1
XFILLER_61_393 VPWR VGND VPWR VGND sky130_ef_sc_hd__decap_12
XFILLER_53_349 VGND VGND VPWR VPWR sky130_fd_sc_hd__fill_1
X_1045_ core_out\[8\] _0375_ VGND VGND VPWR VPWR _0377_ sky130_fd_sc_hd__or2_1
XTAP_TAPCELL_ROW_0_139 VGND VPWR sky130_fd_sc_hd__tapvpwrvgnd_1
X_0829_ _0164_ _0165_ _0166_ VGND VGND VPWR VPWR _0167_ sky130_fd_sc_hd__or3_1
XFILLER_21_268 VPWR VGND VPWR VGND sky130_ef_sc_hd__decap_12
XFILLER_56_165 VPWR VGND VPWR VGND sky130_ef_sc_hd__decap_12
XFILLER_56_121 VPWR VGND VPWR VGND sky130_ef_sc_hd__decap_12
XFILLER_29_335 VGND VGND VPWR VPWR sky130_fd_sc_hd__fill_1
XFILLER_44_45 VPWR VGND VPWR VGND sky130_ef_sc_hd__decap_12
XFILLER_60_77 VGND VGND VPWR VPWR sky130_fd_sc_hd__decap_6
XFILLER_5_39 VPWR VGND VPWR VGND sky130_ef_sc_hd__decap_12
XFILLER_4_401 VGND VGND VPWR VPWR sky130_fd_sc_hd__decap_6
XTAP_TAPCELL_ROW_22_296 VGND VPWR sky130_fd_sc_hd__tapvpwrvgnd_1
XFILLER_47_143 VPWR VGND VPWR VGND sky130_ef_sc_hd__decap_12
XPHY_EDGE_ROW_8_Left_73 VGND VGND VPWR VPWR sky130_fd_sc_hd__decap_3
XFILLER_43_393 VGND VGND VPWR VPWR sky130_fd_sc_hd__decap_4
XTAP_TAPCELL_ROW_13_230 VGND VPWR sky130_fd_sc_hd__tapvpwrvgnd_1
XPHY_EDGE_ROW_7_Right_7 VGND VGND VPWR VPWR sky130_fd_sc_hd__decap_3
XFILLER_53_113 VPWR VGND VPWR VGND sky130_ef_sc_hd__decap_12
XFILLER_38_165 VPWR VGND VPWR VGND sky130_ef_sc_hd__decap_12
XFILLER_38_121 VPWR VGND VPWR VGND sky130_ef_sc_hd__decap_12
XFILLER_26_327 VPWR VGND VPWR VGND sky130_ef_sc_hd__decap_12
XFILLER_14_15 VPWR VGND VPWR VGND sky130_ef_sc_hd__decap_12
X_1028_ _0358_ _0357_ _0350_ VGND VGND VPWR VPWR _0360_ sky130_fd_sc_hd__a21o_1
XFILLER_39_45 VGND VGND VPWR VPWR sky130_fd_sc_hd__decap_8
XFILLER_29_110 VGND VGND VPWR VPWR sky130_fd_sc_hd__fill_2
XPHY_EDGE_ROW_34_Left_99 VGND VGND VPWR VPWR sky130_fd_sc_hd__decap_3
XFILLER_25_393 VGND VGND VPWR VPWR sky130_fd_sc_hd__decap_8
XFILLER_17_305 VPWR VGND VPWR VGND sky130_ef_sc_hd__decap_12
XFILLER_17_349 VPWR VGND VPWR VGND sky130_ef_sc_hd__decap_12
XFILLER_40_352 VPWR VGND VPWR VGND sky130_ef_sc_hd__decap_12
XTAP_TAPCELL_ROW_10_211 VGND VPWR sky130_fd_sc_hd__tapvpwrvgnd_1
XFILLER_4_253 VPWR VGND VPWR VGND sky130_ef_sc_hd__decap_12
XFILLER_35_135 VPWR VGND VPWR VGND sky130_ef_sc_hd__decap_12
XFILLER_35_113 VGND VGND VPWR VPWR sky130_fd_sc_hd__decap_4
XFILLER_50_149 VGND VGND VPWR VPWR sky130_fd_sc_hd__fill_2
XFILLER_50_138 VGND VGND VPWR VPWR sky130_fd_sc_hd__fill_2
XTAP_TAPCELL_ROW_33_369 VGND VPWR sky130_fd_sc_hd__tapvpwrvgnd_1
XTAP_TAPCELL_ROW_49_480 VGND VPWR sky130_fd_sc_hd__tapvpwrvgnd_1
XFILLER_41_105 VGND VGND VPWR VPWR sky130_fd_sc_hd__decap_3
Xrebuffer10 core_b\[0\] VGND VGND VPWR VPWR net126 sky130_fd_sc_hd__dlygate4sd1_1
XFILLER_25_14 VGND VGND VPWR VPWR sky130_fd_sc_hd__fill_2
XFILLER_41_46 VGND VGND VPWR VPWR sky130_fd_sc_hd__decap_8
XFILLER_22_363 VGND VGND VPWR VPWR sky130_fd_sc_hd__fill_1
XFILLER_1_223 VGND VGND VPWR VPWR sky130_fd_sc_hd__fill_1
XFILLER_57_293 VGND VGND VPWR VPWR sky130_fd_sc_hd__fill_1
XFILLER_49_216 VGND VGND VPWR VPWR sky130_fd_sc_hd__decap_8
XFILLER_2_29 VPWR VGND VPWR VGND sky130_ef_sc_hd__decap_12
XFILLER_17_113 VPWR VGND VPWR VGND sky130_ef_sc_hd__decap_12
XFILLER_32_105 VGND VGND VPWR VPWR sky130_fd_sc_hd__decap_3
XFILLER_13_385 VGND VGND VPWR VPWR sky130_fd_sc_hd__decap_6
XFILLER_56_6 VPWR VGND VPWR VGND sky130_ef_sc_hd__decap_12
XFILLER_40_193 VGND VGND VPWR VPWR sky130_fd_sc_hd__decap_3
X_1362_ net100 net173 net112 _0673_ VGND VGND VPWR VPWR _0077_ sky130_fd_sc_hd__o211a_1
X_1293_ core_out\[19\] net53 VGND VGND VPWR VPWR _0614_ sky130_fd_sc_hd__xnor2_1
X_1431_ clknet_3_1__leaf_clk _0047_ VGND VGND VPWR VPWR core_b\[6\] sky130_fd_sc_hd__dfxtp_1
XTAP_TAPCELL_ROW_46_461 VGND VPWR sky130_fd_sc_hd__tapvpwrvgnd_1
XTAP_TAPCELL_ROW_38_406 VGND VPWR sky130_fd_sc_hd__tapvpwrvgnd_1
XFILLER_31_193 VPWR VGND VPWR VGND sky130_ef_sc_hd__decap_12
XFILLER_10_333 VPWR VGND VPWR VGND sky130_ef_sc_hd__decap_12
XFILLER_10_377 VPWR VGND VPWR VGND sky130_ef_sc_hd__decap_12
XFILLER_45_274 VGND VGND VPWR VPWR sky130_fd_sc_hd__decap_6
XFILLER_37_219 VGND VGND VPWR VPWR sky130_fd_sc_hd__fill_2
XFILLER_60_277 VPWR VGND VPWR VGND sky130_ef_sc_hd__decap_12
XFILLER_60_244 VGND VGND VPWR VPWR sky130_fd_sc_hd__decap_8
XTAP_TAPCELL_ROW_43_442 VGND VPWR sky130_fd_sc_hd__tapvpwrvgnd_1
X_0862_ net71 net73 net93 net95 VGND VGND VPWR VPWR _0198_ sky130_fd_sc_hd__and4_1
X_0931_ net126 net83 net85 net77 VGND VGND VPWR VPWR _0265_ sky130_fd_sc_hd__a22oi_2
XFILLER_13_193 VPWR VGND VPWR VGND sky130_ef_sc_hd__decap_12
X_0793_ net163 net107 net59 _0142_ net110 VGND VGND VPWR VPWR _0039_ sky130_fd_sc_hd__o221a_1
XPHY_EDGE_ROW_21_Left_86 VGND VGND VPWR VPWR sky130_fd_sc_hd__decap_3
Xrebuffer1 _0358_ VGND VGND VPWR VPWR net56 sky130_fd_sc_hd__buf_2
X_1345_ net100 _0658_ VGND VGND VPWR VPWR _0659_ sky130_fd_sc_hd__nand2_1
X_1414_ clknet_3_7__leaf_clk _0030_ VGND VGND VPWR VPWR net33 sky130_fd_sc_hd__dfxtp_1
X_1276_ _0580_ _0582_ _0598_ _0599_ VGND VGND VPWR VPWR _0600_ sky130_fd_sc_hd__a31o_1
XFILLER_51_277 VGND VGND VPWR VPWR sky130_fd_sc_hd__decap_3
XFILLER_11_119 VGND VGND VPWR VPWR sky130_fd_sc_hd__fill_1
XFILLER_22_26 VGND VGND VPWR VPWR sky130_fd_sc_hd__fill_2
XFILLER_59_322 VPWR VGND VPWR VGND sky130_ef_sc_hd__decap_12
Xfanout110 net111 VGND VGND VPWR VPWR net110 sky130_fd_sc_hd__buf_2
XFILLER_3_329 VGND VGND VPWR VPWR sky130_fd_sc_hd__decap_6
XFILLER_47_89 VGND VGND VPWR VPWR sky130_fd_sc_hd__fill_2
XFILLER_63_55 VGND VGND VPWR VPWR sky130_fd_sc_hd__fill_1
XFILLER_42_277 VGND VGND VPWR VPWR sky130_fd_sc_hd__decap_8
XFILLER_42_233 VGND VGND VPWR VPWR sky130_fd_sc_hd__decap_8
XTAP_TAPCELL_ROW_40_423 VGND VPWR sky130_fd_sc_hd__tapvpwrvgnd_1
XFILLER_10_141 VPWR VGND VPWR VGND sky130_ef_sc_hd__decap_12
XFILLER_6_189 VGND VGND VPWR VPWR sky130_fd_sc_hd__decap_6
X_1130_ core_out\[10\] _0458_ VGND VGND VPWR VPWR _0460_ sky130_fd_sc_hd__xnor2_1
XFILLER_26_7 VPWR VGND VPWR VGND sky130_ef_sc_hd__decap_12
XFILLER_19_6 VPWR VGND VPWR VGND sky130_ef_sc_hd__decap_12
XFILLER_33_277 VGND VGND VPWR VPWR sky130_fd_sc_hd__decap_3
X_1061_ net72 net82 net84 net70 VGND VGND VPWR VPWR _0392_ sky130_fd_sc_hd__a22o_1
X_0914_ _0247_ _0248_ VGND VGND VPWR VPWR _0249_ sky130_fd_sc_hd__nand2b_1
X_0845_ _0179_ _0180_ _0178_ VGND VGND VPWR VPWR _0182_ sky130_fd_sc_hd__o21ai_1
X_0776_ core_out\[22\] net60 VGND VGND VPWR VPWR _0134_ sky130_fd_sc_hd__and2_1
XTAP_TAPCELL_ROW_54_515 VGND VPWR sky130_fd_sc_hd__tapvpwrvgnd_1
X_1328_ _0618_ _0627_ _0633_ _0638_ VGND VGND VPWR VPWR _0644_ sky130_fd_sc_hd__or4_1
X_1259_ _0583_ _0584_ net98 VGND VGND VPWR VPWR _0585_ sky130_fd_sc_hd__o21ai_1
XTAP_TAPCELL_ROW_3_159 VGND VPWR sky130_fd_sc_hd__tapvpwrvgnd_1
XFILLER_24_288 VGND VGND VPWR VPWR sky130_fd_sc_hd__fill_1
XFILLER_3_137 VPWR VGND VPWR VGND sky130_ef_sc_hd__decap_12
XFILLER_58_77 VGND VGND VPWR VPWR sky130_fd_sc_hd__decap_6
XFILLER_47_325 VGND VGND VPWR VPWR sky130_fd_sc_hd__decap_8
XFILLER_55_391 VGND VGND VPWR VPWR sky130_fd_sc_hd__fill_1
XFILLER_15_266 VPWR VGND VPWR VGND sky130_ef_sc_hd__decap_12
XFILLER_30_258 VPWR VGND VPWR VGND sky130_ef_sc_hd__decap_12
XFILLER_53_306 VPWR VGND VPWR VGND sky130_ef_sc_hd__decap_12
X_1044_ core_out\[8\] _0375_ VGND VGND VPWR VPWR _0376_ sky130_fd_sc_hd__and2_1
XFILLER_38_336 VGND VGND VPWR VPWR sky130_fd_sc_hd__fill_1
X_1113_ _0440_ _0441_ VGND VGND VPWR VPWR _0443_ sky130_fd_sc_hd__and2b_1
XFILLER_61_361 VPWR VGND VPWR VGND sky130_ef_sc_hd__decap_12
XTAP_TAPCELL_ROW_16_250 VGND VPWR sky130_fd_sc_hd__tapvpwrvgnd_1
X_0828_ net78 net91 net92 net76 VGND VGND VPWR VPWR _0166_ sky130_fd_sc_hd__a22oi_2
X_0759_ net152 net106 net57 _0125_ net116 VGND VGND VPWR VPWR _0022_ sky130_fd_sc_hd__o221a_1
XFILLER_28_25 VGND VGND VPWR VPWR sky130_fd_sc_hd__decap_3
XFILLER_56_177 VGND VGND VPWR VPWR sky130_fd_sc_hd__decap_8
XFILLER_56_133 VGND VGND VPWR VPWR sky130_fd_sc_hd__decap_6
XFILLER_52_350 VPWR VGND VPWR VGND sky130_ef_sc_hd__decap_12
XFILLER_44_57 VGND VGND VPWR VPWR sky130_fd_sc_hd__fill_1
XFILLER_28_69 VPWR VGND VPWR VGND sky130_ef_sc_hd__decap_12
XTAP_TAPCELL_ROW_22_297 VGND VPWR sky130_fd_sc_hd__tapvpwrvgnd_1
XFILLER_47_155 VPWR VGND VPWR VGND sky130_ef_sc_hd__decap_12
XFILLER_50_309 VPWR VGND VPWR VGND sky130_ef_sc_hd__decap_12
XFILLER_43_361 VPWR VGND VPWR VGND sky130_ef_sc_hd__decap_12
XTAP_TAPCELL_ROW_13_231 VGND VPWR sky130_fd_sc_hd__tapvpwrvgnd_1
XFILLER_53_169 VPWR VGND VPWR VGND sky130_ef_sc_hd__decap_12
XFILLER_53_125 VPWR VGND VPWR VGND sky130_ef_sc_hd__decap_12
XFILLER_38_177 VPWR VGND VPWR VGND sky130_ef_sc_hd__decap_12
XFILLER_38_133 VGND VGND VPWR VPWR sky130_fd_sc_hd__decap_6
Xclkbuf_3_5__f_clk clknet_0_clk VGND VGND VPWR VPWR clknet_3_5__leaf_clk sky130_fd_sc_hd__clkbuf_16
XFILLER_26_339 VPWR VGND VPWR VGND sky130_ef_sc_hd__decap_12
XFILLER_19_391 VGND VGND VPWR VPWR sky130_fd_sc_hd__fill_1
X_1027_ _0350_ _0357_ _0358_ VGND VGND VPWR VPWR _0359_ sky130_fd_sc_hd__nand3_2
XTAP_TAPCELL_ROW_36_389 VGND VPWR sky130_fd_sc_hd__tapvpwrvgnd_1
XFILLER_14_27 VGND VGND VPWR VPWR sky130_fd_sc_hd__fill_1
XFILLER_30_37 VGND VGND VPWR VPWR sky130_fd_sc_hd__fill_2
XFILLER_1_405 VGND VGND VPWR VPWR sky130_fd_sc_hd__fill_2
XFILLER_39_57 VPWR VGND VPWR VGND sky130_ef_sc_hd__decap_12
XFILLER_29_188 VGND VGND VPWR VPWR sky130_fd_sc_hd__fill_1
XFILLER_17_317 VPWR VGND VPWR VGND sky130_ef_sc_hd__decap_12
XFILLER_25_361 VPWR VGND VPWR VGND sky130_ef_sc_hd__decap_12
XFILLER_4_221 VPWR VGND VPWR VGND sky130_ef_sc_hd__decap_12
XTAP_TAPCELL_ROW_10_212 VGND VPWR sky130_fd_sc_hd__tapvpwrvgnd_1
XFILLER_4_265 VPWR VGND VPWR VGND sky130_ef_sc_hd__decap_12
XFILLER_35_169 VPWR VGND VPWR VGND sky130_ef_sc_hd__decap_12
XFILLER_35_147 VPWR VGND VPWR VGND sky130_ef_sc_hd__decap_12
XFILLER_6_83 VGND VGND VPWR VPWR sky130_fd_sc_hd__fill_1
Xrebuffer11 net126 VGND VGND VPWR VPWR net127 sky130_fd_sc_hd__dlymetal6s2s_1
XTAP_TAPCELL_ROW_49_481 VGND VPWR sky130_fd_sc_hd__tapvpwrvgnd_1
XFILLER_26_169 VGND VGND VPWR VPWR sky130_fd_sc_hd__fill_1
XFILLER_14_309 VPWR VGND VPWR VGND sky130_ef_sc_hd__decap_12
XFILLER_41_69 VPWR VGND VPWR VGND sky130_ef_sc_hd__decap_12
XFILLER_1_279 VGND VGND VPWR VPWR sky130_fd_sc_hd__fill_1
XFILLER_64_209 VGND VGND VPWR VPWR sky130_fd_sc_hd__decap_4
XFILLER_45_401 VGND VGND VPWR VPWR sky130_fd_sc_hd__fill_2
XFILLER_17_125 VGND VGND VPWR VPWR sky130_fd_sc_hd__decap_8
XFILLER_17_147 VGND VGND VPWR VPWR sky130_fd_sc_hd__decap_8
XFILLER_17_169 VPWR VGND VPWR VGND sky130_ef_sc_hd__decap_12
XFILLER_40_161 VPWR VGND VPWR VGND sky130_ef_sc_hd__decap_12
XFILLER_9_335 VGND VGND VPWR VPWR sky130_fd_sc_hd__fill_1
XFILLER_49_6 VPWR VGND VPWR VGND sky130_ef_sc_hd__decap_12
X_1430_ clknet_3_1__leaf_clk _0046_ VGND VGND VPWR VPWR core_b\[5\] sky130_fd_sc_hd__dfxtp_1
X_1361_ net100 _0672_ VGND VGND VPWR VPWR _0673_ sky130_fd_sc_hd__nand2_1
X_1292_ net101 core_out\[18\] net113 _0613_ VGND VGND VPWR VPWR _0067_ sky130_fd_sc_hd__o211a_1
XTAP_TAPCELL_ROW_38_407 VGND VPWR sky130_fd_sc_hd__tapvpwrvgnd_1
XFILLER_63_253 VGND VGND VPWR VPWR sky130_fd_sc_hd__fill_1
XTAP_TAPCELL_ROW_46_462 VGND VPWR sky130_fd_sc_hd__tapvpwrvgnd_1
XFILLER_16_191 VGND VGND VPWR VPWR sky130_fd_sc_hd__decap_4
XFILLER_31_150 VPWR VGND VPWR VGND sky130_ef_sc_hd__decap_12
XFILLER_54_253 VPWR VGND VPWR VGND sky130_ef_sc_hd__decap_12
XFILLER_46_209 VGND VGND VPWR VPWR sky130_fd_sc_hd__decap_4
XFILLER_10_301 VGND VGND VPWR VPWR sky130_fd_sc_hd__decap_6
XFILLER_14_139 VGND VGND VPWR VPWR sky130_fd_sc_hd__fill_1
XFILLER_10_345 VPWR VGND VPWR VGND sky130_ef_sc_hd__decap_12
XFILLER_10_389 VPWR VGND VPWR VGND sky130_ef_sc_hd__decap_12
XFILLER_18_401 VGND VGND VPWR VPWR sky130_fd_sc_hd__decap_6
XTAP_TAPCELL_ROW_43_443 VGND VPWR sky130_fd_sc_hd__tapvpwrvgnd_1
XFILLER_60_289 VGND VGND VPWR VPWR sky130_fd_sc_hd__decap_8
X_0792_ core_out\[30\] net62 VGND VGND VPWR VPWR _0142_ sky130_fd_sc_hd__and2_1
X_0861_ core_b\[3\] net93 net95 net71 VGND VGND VPWR VPWR _0197_ sky130_fd_sc_hd__a22oi_1
XFILLER_42_90 VPWR VGND VPWR VGND sky130_ef_sc_hd__decap_12
X_0930_ net78 net77 net83 net85 VGND VGND VPWR VPWR _0264_ sky130_fd_sc_hd__and4_1
Xrebuffer2 net119 VGND VGND VPWR VPWR net118 sky130_fd_sc_hd__dlymetal6s2s_1
X_1413_ clknet_3_4__leaf_clk _0029_ VGND VGND VPWR VPWR net32 sky130_fd_sc_hd__dfxtp_1
XFILLER_5_393 VPWR VGND VPWR VGND sky130_ef_sc_hd__decap_12
X_1344_ _0655_ _0657_ VGND VGND VPWR VPWR _0658_ sky130_fd_sc_hd__xnor2_2
XFILLER_36_253 VPWR VGND VPWR VGND sky130_ef_sc_hd__decap_12
X_1275_ _0577_ _0592_ VGND VGND VPWR VPWR _0599_ sky130_fd_sc_hd__or2_4
XFILLER_28_209 VGND VGND VPWR VPWR sky130_fd_sc_hd__fill_2
XFILLER_3_51 VGND VGND VPWR VPWR sky130_fd_sc_hd__decap_4
XFILLER_51_289 VGND VGND VPWR VPWR sky130_fd_sc_hd__decap_3
XFILLER_51_223 VGND VGND VPWR VPWR sky130_fd_sc_hd__fill_1
XFILLER_59_334 VGND VGND VPWR VPWR sky130_fd_sc_hd__fill_2
Xfanout111 _0083_ VGND VGND VPWR VPWR net111 sky130_fd_sc_hd__buf_2
Xfanout100 net103 VGND VGND VPWR VPWR net100 sky130_fd_sc_hd__buf_2
XTAP_TAPCELL_ROW_6_179 VGND VPWR sky130_fd_sc_hd__tapvpwrvgnd_1
XFILLER_47_57 VPWR VGND VPWR VGND sky130_ef_sc_hd__decap_12
XPHY_EDGE_ROW_29_Right_29 VGND VGND VPWR VPWR sky130_fd_sc_hd__decap_3
XPHY_EDGE_ROW_38_Right_38 VGND VGND VPWR VPWR sky130_fd_sc_hd__decap_3
XFILLER_8_29 VPWR VGND VPWR VGND sky130_ef_sc_hd__decap_12
XFILLER_10_153 VGND VGND VPWR VPWR sky130_fd_sc_hd__decap_3
XFILLER_10_164 VPWR VGND VPWR VGND sky130_ef_sc_hd__decap_12
XFILLER_2_363 VGND VGND VPWR VPWR sky130_fd_sc_hd__fill_1
XFILLER_10_197 VPWR VGND VPWR VGND sky130_ef_sc_hd__decap_12
XPHY_EDGE_ROW_47_Right_47 VGND VGND VPWR VPWR sky130_fd_sc_hd__decap_3
X_1060_ net70 net72 net82 net84 VGND VGND VPWR VPWR _0391_ sky130_fd_sc_hd__and4_1
XPHY_EDGE_ROW_56_Right_56 VGND VGND VPWR VPWR sky130_fd_sc_hd__decap_3
XFILLER_33_267 VGND VGND VPWR VPWR sky130_fd_sc_hd__decap_3
XFILLER_18_253 VPWR VGND VPWR VGND sky130_ef_sc_hd__decap_12
X_0775_ net142 net105 net58 _0133_ net114 VGND VGND VPWR VPWR _0030_ sky130_fd_sc_hd__o221a_1
X_0913_ _0243_ _0244_ _0246_ core_out\[5\] VGND VGND VPWR VPWR _0248_ sky130_fd_sc_hd__a31o_1
X_0844_ _0178_ _0179_ _0180_ VGND VGND VPWR VPWR _0181_ sky130_fd_sc_hd__or3_1
XTAP_TAPCELL_ROW_54_516 VGND VPWR sky130_fd_sc_hd__tapvpwrvgnd_1
X_1327_ core_out\[23\] core_out\[22\] core_out\[21\] core_out\[20\] net53 VGND VGND
+ VPWR VPWR _0643_ sky130_fd_sc_hd__o41ai_2
Xclone7 _0591_ VGND VGND VPWR VPWR net123 sky130_fd_sc_hd__clkbuf_1
X_1258_ _0578_ _0580_ _0582_ VGND VGND VPWR VPWR _0584_ sky130_fd_sc_hd__and3_1
X_1189_ _0498_ _0516_ VGND VGND VPWR VPWR _0517_ sky130_fd_sc_hd__xnor2_1
XTAP_TAPCELL_ROW_19_270 VGND VPWR sky130_fd_sc_hd__tapvpwrvgnd_1
XTAP_TAPCELL_ROW_62_571 VGND VPWR sky130_fd_sc_hd__tapvpwrvgnd_1
XPHY_EDGE_ROW_49_Left_114 VGND VGND VPWR VPWR sky130_fd_sc_hd__decap_3
XFILLER_33_15 VGND VGND VPWR VPWR sky130_fd_sc_hd__decap_6
XFILLER_3_149 VPWR VGND VPWR VGND sky130_ef_sc_hd__decap_12
XFILLER_3_105 VGND VGND VPWR VPWR sky130_fd_sc_hd__decap_6
XPHY_EDGE_ROW_58_Left_123 VGND VGND VPWR VPWR sky130_fd_sc_hd__decap_3
XFILLER_47_337 VPWR VGND VPWR VGND sky130_ef_sc_hd__decap_12
XFILLER_15_223 VGND VGND VPWR VPWR sky130_fd_sc_hd__fill_1
XFILLER_15_278 VGND VGND VPWR VPWR sky130_fd_sc_hd__fill_2
XFILLER_53_318 VGND VGND VPWR VPWR sky130_fd_sc_hd__fill_2
XFILLER_46_370 VGND VGND VPWR VPWR sky130_fd_sc_hd__fill_2
X_1043_ _0336_ _0374_ VGND VGND VPWR VPWR _0375_ sky130_fd_sc_hd__xor2_1
XFILLER_0_41 VPWR VGND VPWR VGND sky130_ef_sc_hd__decap_12
XFILLER_0_85 VGND VGND VPWR VPWR sky130_fd_sc_hd__fill_2
X_1112_ _0441_ _0440_ VGND VGND VPWR VPWR _0442_ sky130_fd_sc_hd__nand2b_1
XFILLER_61_373 VPWR VGND VPWR VGND sky130_ef_sc_hd__decap_12
XTAP_TAPCELL_ROW_16_251 VGND VPWR sky130_fd_sc_hd__tapvpwrvgnd_1
X_0827_ net76 net78 net91 net92 VGND VGND VPWR VPWR _0165_ sky130_fd_sc_hd__and4_1
X_0758_ core_out\[13\] net61 VGND VGND VPWR VPWR _0125_ sky130_fd_sc_hd__and2_1
XFILLER_29_337 VPWR VGND VPWR VGND sky130_ef_sc_hd__decap_12
XFILLER_52_373 VGND VGND VPWR VPWR sky130_fd_sc_hd__fill_2
XFILLER_52_362 VGND VGND VPWR VPWR sky130_fd_sc_hd__fill_2
XFILLER_44_25 VGND VGND VPWR VPWR sky130_fd_sc_hd__decap_3
XFILLER_37_381 VGND VGND VPWR VPWR sky130_fd_sc_hd__decap_8
XFILLER_60_24 VGND VGND VPWR VPWR sky130_fd_sc_hd__decap_4
XFILLER_12_248 VGND VGND VPWR VPWR sky130_fd_sc_hd__fill_1
XFILLER_47_167 VGND VGND VPWR VPWR sky130_fd_sc_hd__fill_1
XFILLER_43_373 VPWR VGND VPWR VGND sky130_ef_sc_hd__decap_12
XTAP_TAPCELL_ROW_13_232 VGND VPWR sky130_fd_sc_hd__tapvpwrvgnd_1
XFILLER_11_281 VPWR VGND VPWR VGND sky130_ef_sc_hd__decap_12
XFILLER_53_137 VPWR VGND VPWR VGND sky130_ef_sc_hd__decap_12
XFILLER_38_189 VGND VGND VPWR VPWR sky130_fd_sc_hd__decap_6
XFILLER_34_351 VPWR VGND VPWR VGND sky130_ef_sc_hd__decap_12
XFILLER_26_307 VGND VGND VPWR VPWR sky130_fd_sc_hd__fill_1
X_1026_ _0355_ _0354_ _0356_ VGND VGND VPWR VPWR _0358_ sky130_fd_sc_hd__a21o_1
XFILLER_30_27 VGND VGND VPWR VPWR sky130_fd_sc_hd__fill_1
XFILLER_55_57 VPWR VGND VPWR VGND sky130_ef_sc_hd__decap_12
XFILLER_39_69 VGND VGND VPWR VPWR sky130_fd_sc_hd__decap_6
XFILLER_17_329 VGND VGND VPWR VPWR sky130_fd_sc_hd__decap_6
XFILLER_44_159 VPWR VGND VPWR VGND sky130_ef_sc_hd__decap_12
XFILLER_40_365 VGND VGND VPWR VPWR sky130_fd_sc_hd__decap_8
XFILLER_25_373 VGND VGND VPWR VPWR sky130_fd_sc_hd__decap_3
XFILLER_4_233 VPWR VGND VPWR VGND sky130_ef_sc_hd__decap_12
XTAP_TAPCELL_ROW_10_213 VGND VPWR sky130_fd_sc_hd__tapvpwrvgnd_1
XFILLER_20_60 VPWR VGND VPWR VGND sky130_ef_sc_hd__decap_12
XFILLER_4_277 VPWR VGND VPWR VGND sky130_ef_sc_hd__decap_12
XFILLER_35_159 VGND VGND VPWR VPWR sky130_fd_sc_hd__decap_8
XTAP_TAPCELL_ROW_49_482 VGND VPWR sky130_fd_sc_hd__tapvpwrvgnd_1
Xrebuffer12 _0351_ VGND VGND VPWR VPWR net128 sky130_fd_sc_hd__dlygate4sd1_1
X_1009_ _0339_ _0340_ VGND VGND VPWR VPWR _0341_ sky130_fd_sc_hd__or2_1
XFILLER_22_321 VPWR VGND VPWR VGND sky130_ef_sc_hd__decap_12
XFILLER_22_365 VPWR VGND VPWR VGND sky130_ef_sc_hd__decap_12
XTAP_TAPCELL_ROW_24_305 VGND VPWR sky130_fd_sc_hd__tapvpwrvgnd_1
XFILLER_1_225 VPWR VGND VPWR VGND sky130_ef_sc_hd__decap_12
XFILLER_40_173 VPWR VGND VPWR VGND sky130_ef_sc_hd__decap_12
XFILLER_15_71 VGND VGND VPWR VPWR sky130_fd_sc_hd__decap_3
XFILLER_25_192 VPWR VGND VPWR VGND sky130_ef_sc_hd__decap_12
X_1360_ _0667_ _0670_ VGND VGND VPWR VPWR _0672_ sky130_fd_sc_hd__xnor2_1
XFILLER_48_251 VGND VGND VPWR VPWR sky130_fd_sc_hd__fill_1
XFILLER_48_240 VGND VGND VPWR VPWR sky130_fd_sc_hd__decap_4
X_1291_ net101 _0612_ VGND VGND VPWR VPWR _0613_ sky130_fd_sc_hd__nand2_1
XTAP_TAPCELL_ROW_38_408 VGND VPWR sky130_fd_sc_hd__tapvpwrvgnd_1
XTAP_TAPCELL_ROW_46_463 VGND VPWR sky130_fd_sc_hd__tapvpwrvgnd_1
XFILLER_31_162 VGND VGND VPWR VPWR sky130_fd_sc_hd__decap_6
XFILLER_11_18 VGND VGND VPWR VPWR sky130_fd_sc_hd__decap_6
XFILLER_54_265 VPWR VGND VPWR VGND sky130_ef_sc_hd__decap_12
XFILLER_39_273 VGND VGND VPWR VPWR sky130_fd_sc_hd__decap_6
XFILLER_27_402 VGND VGND VPWR VPWR sky130_fd_sc_hd__fill_1
XFILLER_10_357 VGND VGND VPWR VPWR sky130_fd_sc_hd__decap_6
XFILLER_7_3 VPWR VGND VPWR VGND sky130_ef_sc_hd__decap_12
XTAP_TAPCELL_ROW_43_444 VGND VPWR sky130_fd_sc_hd__tapvpwrvgnd_1
XFILLER_33_405 VGND VGND VPWR VPWR sky130_fd_sc_hd__fill_2
XFILLER_26_81 VGND VGND VPWR VPWR sky130_fd_sc_hd__decap_3
XFILLER_13_140 VPWR VGND VPWR VGND sky130_ef_sc_hd__decap_12
X_0791_ net149 net107 net59 _0141_ net111 VGND VGND VPWR VPWR _0038_ sky130_fd_sc_hd__o221a_1
X_0860_ net96 net172 net110 _0196_ VGND VGND VPWR VPWR _0052_ sky130_fd_sc_hd__o211a_1
XFILLER_9_111 VGND VGND VPWR VPWR sky130_fd_sc_hd__fill_1
XFILLER_13_162 VGND VGND VPWR VPWR sky130_fd_sc_hd__decap_6
Xrebuffer3 _0400_ VGND VGND VPWR VPWR net119 sky130_fd_sc_hd__dlymetal6s2s_1
X_1343_ core_out\[25\] net53 _0656_ _0646_ VGND VGND VPWR VPWR _0657_ sky130_fd_sc_hd__a2bb2o_4
X_1412_ clknet_3_4__leaf_clk _0028_ VGND VGND VPWR VPWR net30 sky130_fd_sc_hd__dfxtp_1
XFILLER_5_361 VPWR VGND VPWR VGND sky130_ef_sc_hd__decap_12
XFILLER_36_287 VPWR VGND VPWR VGND sky130_ef_sc_hd__decap_12
XFILLER_36_265 VGND VGND VPWR VPWR sky130_fd_sc_hd__fill_1
X_1274_ _0575_ _0592_ _0593_ VGND VGND VPWR VPWR _0598_ sky130_fd_sc_hd__o21ba_4
X_0989_ _0317_ _0319_ _0275_ _0278_ VGND VGND VPWR VPWR _0322_ sky130_fd_sc_hd__o211ai_2
Xfanout112 net115 VGND VGND VPWR VPWR net112 sky130_fd_sc_hd__buf_2
XTAP_TAPCELL_ROW_57_536 VGND VPWR sky130_fd_sc_hd__tapvpwrvgnd_1
Xfanout101 net103 VGND VGND VPWR VPWR net101 sky130_fd_sc_hd__buf_2
XFILLER_47_69 VPWR VGND VPWR VGND sky130_ef_sc_hd__decap_12
XFILLER_47_25 VPWR VGND VPWR VGND sky130_ef_sc_hd__decap_12
XFILLER_63_57 VPWR VGND VPWR VGND sky130_ef_sc_hd__decap_12
XFILLER_15_405 VGND VGND VPWR VPWR sky130_fd_sc_hd__fill_2
XFILLER_10_121 VPWR VGND VPWR VGND sky130_ef_sc_hd__decap_12
XFILLER_10_176 VPWR VGND VPWR VGND sky130_ef_sc_hd__decap_12
XFILLER_18_265 VPWR VGND VPWR VGND sky130_ef_sc_hd__decap_12
X_0912_ core_out\[5\] _0243_ _0244_ _0246_ VGND VGND VPWR VPWR _0247_ sky130_fd_sc_hd__and4_1
X_0774_ core_out\[21\] net60 VGND VGND VPWR VPWR _0133_ sky130_fd_sc_hd__and2_1
X_0843_ net127 net88 net91 net76 VGND VGND VPWR VPWR _0180_ sky130_fd_sc_hd__a22oi_2
XFILLER_56_327 VGND VGND VPWR VPWR sky130_fd_sc_hd__decap_6
X_1326_ core_out\[24\] net53 VGND VGND VPWR VPWR _0642_ sky130_fd_sc_hd__xnor2_1
XFILLER_64_393 VPWR VGND VPWR VGND sky130_ef_sc_hd__decap_12
XTAP_TAPCELL_ROW_54_517 VGND VPWR sky130_fd_sc_hd__tapvpwrvgnd_1
XFILLER_49_390 VGND VGND VPWR VPWR sky130_fd_sc_hd__fill_2
X_1257_ _0580_ _0582_ _0578_ VGND VGND VPWR VPWR _0583_ sky130_fd_sc_hd__a21oi_1
X_1188_ _0514_ _0515_ VGND VGND VPWR VPWR _0516_ sky130_fd_sc_hd__nor2_1
XTAP_TAPCELL_ROW_19_271 VGND VPWR sky130_fd_sc_hd__tapvpwrvgnd_1
XTAP_TAPCELL_ROW_62_572 VGND VPWR sky130_fd_sc_hd__tapvpwrvgnd_1
XFILLER_59_121 VPWR VGND VPWR VGND sky130_ef_sc_hd__decap_12
XFILLER_47_349 VPWR VGND VPWR VGND sky130_ef_sc_hd__decap_12
XFILLER_55_393 VPWR VGND VPWR VGND sky130_ef_sc_hd__decap_12
XFILLER_23_71 VGND VGND VPWR VPWR sky130_fd_sc_hd__fill_1
XFILLER_38_305 VGND VGND VPWR VPWR sky130_fd_sc_hd__decap_3
XFILLER_46_360 VGND VGND VPWR VPWR sky130_fd_sc_hd__decap_4
X_1042_ _0372_ _0373_ VGND VGND VPWR VPWR _0374_ sky130_fd_sc_hd__and2b_1
XFILLER_0_53 VGND VGND VPWR VPWR sky130_fd_sc_hd__decap_3
X_1111_ _0394_ _0400_ _0398_ VGND VGND VPWR VPWR _0441_ sky130_fd_sc_hd__a21oi_1
XFILLER_61_385 VGND VGND VPWR VPWR sky130_fd_sc_hd__decap_6
XFILLER_9_51 VGND VGND VPWR VPWR sky130_fd_sc_hd__decap_4
XTAP_TAPCELL_ROW_16_252 VGND VPWR sky130_fd_sc_hd__tapvpwrvgnd_1
X_0826_ net75 net94 VGND VGND VPWR VPWR _0164_ sky130_fd_sc_hd__nand2_1
X_0757_ net162 net106 net57 _0124_ net116 VGND VGND VPWR VPWR _0021_ sky130_fd_sc_hd__o221a_1
X_1309_ core_out\[20\] net53 _0624_ VGND VGND VPWR VPWR _0628_ sky130_fd_sc_hd__a21bo_1
XFILLER_29_349 VGND VGND VPWR VPWR sky130_fd_sc_hd__decap_6
XFILLER_20_271 VGND VGND VPWR VPWR sky130_fd_sc_hd__fill_1
XFILLER_47_113 VPWR VGND VPWR VGND sky130_ef_sc_hd__decap_12
XFILLER_18_82 VGND VGND VPWR VPWR sky130_fd_sc_hd__fill_2
XFILLER_43_385 VGND VGND VPWR VPWR sky130_fd_sc_hd__decap_6
XFILLER_34_92 VPWR VGND VPWR VGND sky130_ef_sc_hd__decap_12
XFILLER_11_293 VPWR VGND VPWR VGND sky130_ef_sc_hd__decap_12
XTAP_TAPCELL_ROW_13_233 VGND VPWR sky130_fd_sc_hd__tapvpwrvgnd_1
XFILLER_53_149 VPWR VGND VPWR VGND sky130_ef_sc_hd__decap_12
XFILLER_34_385 VGND VGND VPWR VPWR sky130_fd_sc_hd__fill_2
XFILLER_34_363 VGND VGND VPWR VPWR sky130_fd_sc_hd__fill_1
XFILLER_14_29 VGND VGND VPWR VPWR sky130_fd_sc_hd__decap_3
XFILLER_19_393 VPWR VGND VPWR VGND sky130_ef_sc_hd__decap_12
X_1025_ _0354_ _0355_ _0356_ VGND VGND VPWR VPWR _0357_ sky130_fd_sc_hd__nand3_1
X_0809_ net66 net17 _0144_ VGND VGND VPWR VPWR _0151_ sky130_fd_sc_hd__mux2_1
XFILLER_29_102 VGND VGND VPWR VPWR sky130_fd_sc_hd__decap_8
XFILLER_55_69 VPWR VGND VPWR VGND sky130_ef_sc_hd__decap_12
XFILLER_29_113 VGND VGND VPWR VPWR sky130_fd_sc_hd__decap_4
XFILLER_4_289 VPWR VGND VPWR VGND sky130_ef_sc_hd__decap_12
XFILLER_4_245 VGND VGND VPWR VPWR sky130_fd_sc_hd__decap_6
XFILLER_20_72 VPWR VGND VPWR VGND sky130_ef_sc_hd__decap_12
XFILLER_16_363 VGND VGND VPWR VPWR sky130_fd_sc_hd__fill_1
XFILLER_31_355 VPWR VGND VPWR VGND sky130_ef_sc_hd__decap_12
XANTENNA_1 _0101_ VGND VGND VPWR VPWR sky130_fd_sc_hd__diode_2
XFILLER_6_41 VPWR VGND VPWR VGND sky130_ef_sc_hd__decap_12
XFILLER_6_85 VPWR VGND VPWR VGND sky130_ef_sc_hd__decap_12
XTAP_TAPCELL_ROW_49_483 VGND VPWR sky130_fd_sc_hd__tapvpwrvgnd_1
XFILLER_26_138 VGND VGND VPWR VPWR sky130_fd_sc_hd__fill_2
XFILLER_26_105 VGND VGND VPWR VPWR sky130_fd_sc_hd__decap_8
Xrebuffer13 _0351_ VGND VGND VPWR VPWR net129 sky130_fd_sc_hd__dlymetal6s4s_1
XFILLER_41_119 VPWR VGND VPWR VGND sky130_ef_sc_hd__decap_12
XTAP_TAPCELL_ROW_32_361 VGND VPWR sky130_fd_sc_hd__tapvpwrvgnd_1
XFILLER_22_333 VPWR VGND VPWR VGND sky130_ef_sc_hd__decap_12
XFILLER_22_377 VPWR VGND VPWR VGND sky130_ef_sc_hd__decap_12
XTAP_TAPCELL_ROW_24_306 VGND VPWR sky130_fd_sc_hd__tapvpwrvgnd_1
X_1008_ net93 net90 net67 core_b\[7\] VGND VGND VPWR VPWR _0340_ sky130_fd_sc_hd__and4b_1
XFILLER_57_241 VGND VGND VPWR VPWR sky130_fd_sc_hd__fill_1
XFILLER_1_237 VPWR VGND VPWR VGND sky130_ef_sc_hd__decap_12
XFILLER_40_185 VGND VGND VPWR VPWR sky130_fd_sc_hd__decap_8
XFILLER_40_141 VPWR VGND VPWR VGND sky130_ef_sc_hd__decap_12
XFILLER_9_337 VPWR VGND VPWR VGND sky130_ef_sc_hd__decap_12
X_1290_ _0609_ _0611_ VGND VGND VPWR VPWR _0612_ sky130_fd_sc_hd__xnor2_2
XTAP_TAPCELL_ROW_38_409 VGND VPWR sky130_fd_sc_hd__tapvpwrvgnd_1
XFILLER_0_281 VPWR VGND VPWR VGND sky130_ef_sc_hd__decap_12
XTAP_TAPCELL_ROW_46_464 VGND VPWR sky130_fd_sc_hd__tapvpwrvgnd_1
XFILLER_39_241 VGND VGND VPWR VPWR sky130_fd_sc_hd__fill_1
XFILLER_54_277 VPWR VGND VPWR VGND sky130_ef_sc_hd__decap_12
XFILLER_36_27 VGND VGND VPWR VPWR sky130_fd_sc_hd__fill_1
XFILLER_52_59 VGND VGND VPWR VPWR sky130_fd_sc_hd__decap_4
XFILLER_52_37 VGND VGND VPWR VPWR sky130_fd_sc_hd__fill_2
XFILLER_6_307 VGND VGND VPWR VPWR sky130_fd_sc_hd__fill_1
XFILLER_45_233 VPWR VGND VPWR VGND sky130_ef_sc_hd__decap_12
XFILLER_26_93 VPWR VGND VPWR VGND sky130_ef_sc_hd__decap_12
XFILLER_13_152 VGND VGND VPWR VPWR sky130_fd_sc_hd__fill_2
X_0790_ core_out\[29\] net62 VGND VGND VPWR VPWR _0141_ sky130_fd_sc_hd__and2_1
XFILLER_54_6 VPWR VGND VPWR VGND sky130_ef_sc_hd__decap_12
Xrebuffer4 _0591_ VGND VGND VPWR VPWR net120 sky130_fd_sc_hd__dlygate4sd1_1
XFILLER_5_373 VPWR VGND VPWR VGND sky130_ef_sc_hd__decap_12
X_1342_ core_out\[25\] core_out\[24\] net53 VGND VGND VPWR VPWR _0656_ sky130_fd_sc_hd__o21ai_1
X_1411_ clknet_3_4__leaf_clk _0027_ VGND VGND VPWR VPWR net29 sky130_fd_sc_hd__dfxtp_1
X_1273_ core_out\[16\] net55 VGND VGND VPWR VPWR _0597_ sky130_fd_sc_hd__xnor2_4
XFILLER_51_225 VPWR VGND VPWR VGND sky130_ef_sc_hd__decap_12
XFILLER_36_299 VGND VGND VPWR VPWR sky130_fd_sc_hd__decap_8
X_0988_ _0320_ VGND VGND VPWR VPWR _0321_ sky130_fd_sc_hd__inv_2
XFILLER_22_29 VGND VGND VPWR VPWR sky130_fd_sc_hd__fill_2
Xfanout102 net103 VGND VGND VPWR VPWR net102 sky130_fd_sc_hd__dlymetal6s2s_1
Xfanout113 net114 VGND VGND VPWR VPWR net113 sky130_fd_sc_hd__buf_2
XTAP_TAPCELL_ROW_57_537 VGND VPWR sky130_fd_sc_hd__tapvpwrvgnd_1
XFILLER_47_37 VPWR VGND VPWR VGND sky130_ef_sc_hd__decap_12
XFILLER_63_69 VPWR VGND VPWR VGND sky130_ef_sc_hd__decap_12
XFILLER_10_133 VGND VGND VPWR VPWR sky130_fd_sc_hd__decap_6
XFILLER_10_188 VGND VGND VPWR VPWR sky130_fd_sc_hd__decap_8
XFILLER_2_365 VPWR VGND VPWR VGND sky130_ef_sc_hd__decap_12
XFILLER_2_321 VPWR VGND VPWR VGND sky130_ef_sc_hd__decap_12
XFILLER_33_225 VPWR VGND VPWR VGND sky130_ef_sc_hd__decap_12
XFILLER_18_211 VPWR VGND VPWR VGND sky130_ef_sc_hd__decap_12
XFILLER_18_277 VPWR VGND VPWR VGND sky130_ef_sc_hd__decap_12
X_0911_ _0213_ _0242_ VGND VGND VPWR VPWR _0246_ sky130_fd_sc_hd__or2_1
X_0842_ net76 net78 net88 net91 VGND VGND VPWR VPWR _0179_ sky130_fd_sc_hd__and4_1
XFILLER_33_247 VGND VGND VPWR VPWR sky130_fd_sc_hd__decap_6
X_0773_ net141 net105 net58 _0132_ net113 VGND VGND VPWR VPWR _0029_ sky130_fd_sc_hd__o221a_1
XFILLER_5_181 VPWR VGND VPWR VGND sky130_ef_sc_hd__decap_12
X_1325_ _0640_ net102 _0641_ net9 VGND VGND VPWR VPWR _0072_ sky130_fd_sc_hd__a211oi_1
X_1256_ core_out\[13\] _0554_ _0581_ VGND VGND VPWR VPWR _0582_ sky130_fd_sc_hd__o21ai_2
XFILLER_17_18 VPWR VGND VPWR VGND sky130_ef_sc_hd__decap_12
XFILLER_64_361 VGND VGND VPWR VPWR sky130_fd_sc_hd__decap_3
XTAP_TAPCELL_ROW_62_573 VGND VPWR sky130_fd_sc_hd__tapvpwrvgnd_1
XTAP_TAPCELL_ROW_54_518 VGND VPWR sky130_fd_sc_hd__tapvpwrvgnd_1
X_1187_ _0479_ _0481_ _0513_ VGND VGND VPWR VPWR _0515_ sky130_fd_sc_hd__and3_1
XTAP_TAPCELL_ROW_19_272 VGND VPWR sky130_fd_sc_hd__tapvpwrvgnd_1
XFILLER_24_269 VGND VGND VPWR VPWR sky130_fd_sc_hd__fill_1
XFILLER_32_280 VGND VGND VPWR VPWR sky130_fd_sc_hd__decap_4
XFILLER_59_133 VPWR VGND VPWR VGND sky130_ef_sc_hd__decap_12
XFILLER_55_361 VPWR VGND VPWR VGND sky130_ef_sc_hd__decap_12
XTAP_TAPCELL_ROW_2_151 VGND VPWR sky130_fd_sc_hd__tapvpwrvgnd_1
XFILLER_15_225 VPWR VGND VPWR VGND sky130_ef_sc_hd__decap_12
XFILLER_23_291 VGND VGND VPWR VPWR sky130_fd_sc_hd__decap_4
XFILLER_2_195 VGND VGND VPWR VPWR sky130_fd_sc_hd__fill_1
XFILLER_17_6 VPWR VGND VPWR VGND sky130_ef_sc_hd__decap_12
X_1110_ _0432_ _0439_ VGND VGND VPWR VPWR _0440_ sky130_fd_sc_hd__xnor2_1
X_1041_ _0371_ _0370_ _0321_ _0323_ VGND VGND VPWR VPWR _0373_ sky130_fd_sc_hd__a211o_1
XFILLER_0_98 VGND VGND VPWR VPWR sky130_fd_sc_hd__decap_3
XTAP_TAPCELL_ROW_16_253 VGND VPWR sky130_fd_sc_hd__tapvpwrvgnd_1
XFILLER_21_217 VGND VGND VPWR VPWR sky130_fd_sc_hd__decap_6
X_0825_ net97 net170 net109 _0163_ VGND VGND VPWR VPWR _0050_ sky130_fd_sc_hd__o211a_1
X_0756_ core_out\[12\] net61 VGND VGND VPWR VPWR _0124_ sky130_fd_sc_hd__and2_1
X_1308_ core_out\[21\] net53 VGND VGND VPWR VPWR _0627_ sky130_fd_sc_hd__xnor2_1
XFILLER_44_309 VPWR VGND VPWR VGND sky130_ef_sc_hd__decap_12
X_1239_ _0563_ _0534_ _0537_ VGND VGND VPWR VPWR _0565_ sky130_fd_sc_hd__mux2_1
XFILLER_60_15 VGND VGND VPWR VPWR sky130_fd_sc_hd__decap_6
XFILLER_20_250 VGND VGND VPWR VPWR sky130_fd_sc_hd__fill_2
XFILLER_47_125 VGND VGND VPWR VPWR sky130_fd_sc_hd__decap_4
XFILLER_62_139 VGND VGND VPWR VPWR sky130_fd_sc_hd__fill_1
XFILLER_47_169 VPWR VGND VPWR VGND sky130_ef_sc_hd__decap_12
XTAP_TAPCELL_ROW_13_234 VGND VPWR sky130_fd_sc_hd__tapvpwrvgnd_1
XFILLER_50_81 VGND VGND VPWR VPWR sky130_fd_sc_hd__decap_3
X_1024_ _0263_ _0306_ _0307_ VGND VGND VPWR VPWR _0356_ sky130_fd_sc_hd__o21bai_1
XFILLER_19_361 VPWR VGND VPWR VGND sky130_ef_sc_hd__decap_12
XFILLER_61_161 VGND VGND VPWR VPWR sky130_fd_sc_hd__decap_6
XPHY_EDGE_ROW_28_Left_93 VGND VGND VPWR VPWR sky130_fd_sc_hd__decap_3
XFILLER_30_29 VGND VGND VPWR VPWR sky130_fd_sc_hd__decap_8
XPHY_EDGE_ROW_12_Left_77 VGND VGND VPWR VPWR sky130_fd_sc_hd__decap_3
X_0808_ net108 _0150_ VGND VGND VPWR VPWR _0046_ sky130_fd_sc_hd__and2_1
X_0739_ net85 net63 _0100_ net69 VGND VGND VPWR VPWR _0114_ sky130_fd_sc_hd__a22o_1
XFILLER_44_139 VGND VGND VPWR VPWR sky130_fd_sc_hd__fill_1
XTAP_TAPCELL_ROW_27_326 VGND VPWR sky130_fd_sc_hd__tapvpwrvgnd_1
Xhold60 core_out\[11\] VGND VGND VPWR VPWR net176 sky130_fd_sc_hd__dlygate4sd3_1
XFILLER_50_109 VGND VGND VPWR VPWR sky130_fd_sc_hd__decap_6
XFILLER_45_70 VGND VGND VPWR VPWR sky130_fd_sc_hd__decap_8
XFILLER_31_378 VGND VGND VPWR VPWR sky130_fd_sc_hd__decap_4
XFILLER_31_367 VGND VGND VPWR VPWR sky130_fd_sc_hd__decap_6
XFILLER_31_345 VGND VGND VPWR VPWR sky130_fd_sc_hd__fill_2
XFILLER_6_53 VPWR VGND VPWR VGND sky130_ef_sc_hd__decap_12
XFILLER_6_97 VPWR VGND VPWR VGND sky130_ef_sc_hd__decap_12
XTAP_TAPCELL_ROW_49_484 VGND VPWR sky130_fd_sc_hd__tapvpwrvgnd_1
Xrebuffer14 net129 VGND VGND VPWR VPWR net130 sky130_fd_sc_hd__dlygate4sd1_1
XTAP_TAPCELL_ROW_24_307 VGND VPWR sky130_fd_sc_hd__tapvpwrvgnd_1
X_1007_ net67 net90 net93 _0081_ VGND VGND VPWR VPWR _0339_ sky130_fd_sc_hd__o2bb2a_1
XFILLER_41_28 VGND VGND VPWR VPWR sky130_fd_sc_hd__decap_3
XTAP_TAPCELL_ROW_32_362 VGND VPWR sky130_fd_sc_hd__tapvpwrvgnd_1
XFILLER_22_345 VPWR VGND VPWR VGND sky130_ef_sc_hd__decap_12
XFILLER_22_389 VPWR VGND VPWR VGND sky130_ef_sc_hd__decap_12
XFILLER_1_205 VPWR VGND VPWR VGND sky130_ef_sc_hd__decap_12
XFILLER_1_249 VPWR VGND VPWR VGND sky130_ef_sc_hd__decap_12
XFILLER_57_275 VGND VGND VPWR VPWR sky130_fd_sc_hd__decap_4
XFILLER_57_220 VGND VGND VPWR VPWR sky130_fd_sc_hd__decap_4
XFILLER_9_305 VPWR VGND VPWR VGND sky130_ef_sc_hd__decap_12
XFILLER_40_197 VGND VGND VPWR VPWR sky130_fd_sc_hd__decap_8
XFILLER_9_349 VPWR VGND VPWR VGND sky130_ef_sc_hd__decap_12
XFILLER_15_95 VGND VGND VPWR VPWR sky130_fd_sc_hd__decap_8
Xoutput50 net50 VGND VGND VPWR VPWR rdata[8] sky130_fd_sc_hd__buf_2
XFILLER_63_278 VGND VGND VPWR VPWR sky130_fd_sc_hd__fill_2
XFILLER_63_201 VGND VGND VPWR VPWR sky130_fd_sc_hd__fill_1
XFILLER_48_253 VPWR VGND VPWR VGND sky130_ef_sc_hd__decap_12
XTAP_TAPCELL_ROW_46_465 VGND VPWR sky130_fd_sc_hd__tapvpwrvgnd_1
XFILLER_0_293 VPWR VGND VPWR VGND sky130_ef_sc_hd__decap_12
XFILLER_16_183 VGND VGND VPWR VPWR sky130_fd_sc_hd__fill_1
XFILLER_54_289 VPWR VGND VPWR VGND sky130_ef_sc_hd__decap_12
XFILLER_52_27 VGND VGND VPWR VPWR sky130_fd_sc_hd__fill_1
XFILLER_14_109 VPWR VGND VPWR VGND sky130_ef_sc_hd__decap_12
XFILLER_22_197 VGND VGND VPWR VPWR sky130_fd_sc_hd__decap_6
XPHY_EDGE_ROW_15_Left_80 VGND VGND VPWR VPWR sky130_fd_sc_hd__decap_3
XFILLER_45_245 VGND VGND VPWR VPWR sky130_fd_sc_hd__fill_1
XFILLER_45_223 VGND VGND VPWR VPWR sky130_fd_sc_hd__fill_1
XFILLER_26_50 VGND VGND VPWR VPWR sky130_fd_sc_hd__fill_2
XFILLER_9_113 VPWR VGND VPWR VGND sky130_ef_sc_hd__decap_12
X_1410_ clknet_3_4__leaf_clk _0026_ VGND VGND VPWR VPWR net28 sky130_fd_sc_hd__dfxtp_1
XFILLER_5_385 VGND VGND VPWR VPWR sky130_fd_sc_hd__decap_6
Xrebuffer5 _0524_ VGND VGND VPWR VPWR net121 sky130_fd_sc_hd__clkbuf_2
X_1341_ _0653_ _0654_ VGND VGND VPWR VPWR _0655_ sky130_fd_sc_hd__nand2_1
X_1272_ net98 net179 _0595_ _0596_ net113 VGND VGND VPWR VPWR _0064_ sky130_fd_sc_hd__o221a_1
XFILLER_51_237 VGND VGND VPWR VPWR sky130_fd_sc_hd__decap_3
X_0987_ _0275_ _0278_ _0319_ _0317_ VGND VGND VPWR VPWR _0320_ sky130_fd_sc_hd__a211o_1
Xfanout114 net115 VGND VGND VPWR VPWR net114 sky130_fd_sc_hd__clkbuf_4
XFILLER_59_337 VPWR VGND VPWR VGND sky130_ef_sc_hd__decap_12
Xfanout103 net104 VGND VGND VPWR VPWR net103 sky130_fd_sc_hd__dlymetal6s2s_1
XFILLER_63_15 VPWR VGND VPWR VGND sky130_ef_sc_hd__decap_12
XTAP_TAPCELL_ROW_57_538 VGND VPWR sky130_fd_sc_hd__tapvpwrvgnd_1
XFILLER_47_49 VGND VGND VPWR VPWR sky130_fd_sc_hd__decap_6
XFILLER_27_223 VGND VGND VPWR VPWR sky130_fd_sc_hd__fill_1
XFILLER_50_292 VGND VGND VPWR VPWR sky130_fd_sc_hd__decap_8
XFILLER_12_85 VGND VGND VPWR VPWR sky130_fd_sc_hd__decap_4
XFILLER_2_377 VPWR VGND VPWR VGND sky130_ef_sc_hd__decap_12
XFILLER_2_333 VPWR VGND VPWR VGND sky130_ef_sc_hd__decap_12
XPHY_EDGE_ROW_0_Left_65 VGND VGND VPWR VPWR sky130_fd_sc_hd__decap_3
XFILLER_33_237 VGND VGND VPWR VPWR sky130_fd_sc_hd__fill_2
XPHY_EDGE_ROW_16_Right_16 VGND VGND VPWR VPWR sky130_fd_sc_hd__decap_3
XFILLER_18_223 VPWR VGND VPWR VGND sky130_ef_sc_hd__decap_12
XFILLER_18_289 VPWR VGND VPWR VGND sky130_ef_sc_hd__decap_12
XFILLER_53_81 VPWR VGND VPWR VGND sky130_ef_sc_hd__decap_12
X_0772_ core_out\[20\] net60 VGND VGND VPWR VPWR _0132_ sky130_fd_sc_hd__and2_1
X_0910_ _0213_ _0242_ VGND VGND VPWR VPWR _0245_ sky130_fd_sc_hd__nor2_1
X_0841_ net75 net92 VGND VGND VPWR VPWR _0178_ sky130_fd_sc_hd__nand2_1
XPHY_EDGE_ROW_25_Right_25 VGND VGND VPWR VPWR sky130_fd_sc_hd__decap_3
XFILLER_5_193 VPWR VGND VPWR VGND sky130_ef_sc_hd__decap_12
X_1324_ net102 core_out\[23\] VGND VGND VPWR VPWR _0641_ sky130_fd_sc_hd__nor2_1
XFILLER_56_307 VGND VGND VPWR VPWR sky130_fd_sc_hd__fill_1
XPHY_EDGE_ROW_34_Right_34 VGND VGND VPWR VPWR sky130_fd_sc_hd__decap_3
X_1255_ core_out\[13\] _0554_ _0527_ VGND VGND VPWR VPWR _0581_ sky130_fd_sc_hd__a21o_1
X_1186_ _0479_ _0481_ _0513_ VGND VGND VPWR VPWR _0514_ sky130_fd_sc_hd__a21oi_1
XTAP_TAPCELL_ROW_62_574 VGND VPWR sky130_fd_sc_hd__tapvpwrvgnd_1
XTAP_TAPCELL_ROW_54_519 VGND VPWR sky130_fd_sc_hd__tapvpwrvgnd_1
XTAP_TAPCELL_ROW_19_273 VGND VPWR sky130_fd_sc_hd__tapvpwrvgnd_1
XPHY_EDGE_ROW_43_Right_43 VGND VGND VPWR VPWR sky130_fd_sc_hd__decap_3
XFILLER_59_167 VGND VGND VPWR VPWR sky130_fd_sc_hd__fill_1
XFILLER_59_145 VGND VGND VPWR VPWR sky130_fd_sc_hd__fill_1
XFILLER_58_15 VPWR VGND VPWR VGND sky130_ef_sc_hd__decap_12
XPHY_EDGE_ROW_52_Right_52 VGND VGND VPWR VPWR sky130_fd_sc_hd__decap_3
XFILLER_55_373 VPWR VGND VPWR VGND sky130_ef_sc_hd__decap_12
XTAP_TAPCELL_ROW_2_152 VGND VPWR sky130_fd_sc_hd__tapvpwrvgnd_1
XFILLER_15_215 VGND VGND VPWR VPWR sky130_fd_sc_hd__decap_8
XFILLER_15_237 VPWR VGND VPWR VGND sky130_ef_sc_hd__decap_12
XPHY_EDGE_ROW_61_Right_61 VGND VGND VPWR VPWR sky130_fd_sc_hd__decap_3
XPHY_EDGE_ROW_36_Left_101 VGND VGND VPWR VPWR sky130_fd_sc_hd__decap_3
XFILLER_23_281 VGND VGND VPWR VPWR sky130_fd_sc_hd__decap_3
XFILLER_2_141 VPWR VGND VPWR VGND sky130_ef_sc_hd__decap_12
XPHY_EDGE_ROW_45_Left_110 VGND VGND VPWR VPWR sky130_fd_sc_hd__decap_3
X_1040_ _0321_ _0323_ _0370_ _0371_ VGND VGND VPWR VPWR _0372_ sky130_fd_sc_hd__o211a_1
XTAP_TAPCELL_ROW_16_254 VGND VPWR sky130_fd_sc_hd__tapvpwrvgnd_1
X_0824_ net97 _0162_ VGND VGND VPWR VPWR _0163_ sky130_fd_sc_hd__nand2_1
X_0755_ net164 net106 net57 _0123_ net116 VGND VGND VPWR VPWR _0020_ sky130_fd_sc_hd__o221a_1
XFILLER_9_86 VPWR VGND VPWR VGND sky130_ef_sc_hd__decap_12
XFILLER_28_29 VPWR VGND VPWR VGND sky130_ef_sc_hd__decap_12
XFILLER_64_181 VGND VGND VPWR VPWR sky130_fd_sc_hd__decap_4
XFILLER_52_321 VGND VGND VPWR VPWR sky130_fd_sc_hd__decap_3
X_1307_ net101 net181 net114 _0626_ VGND VGND VPWR VPWR _0069_ sky130_fd_sc_hd__o211a_1
XFILLER_44_17 VGND VGND VPWR VPWR sky130_fd_sc_hd__decap_8
X_1169_ _0492_ _0494_ VGND VGND VPWR VPWR _0497_ sky130_fd_sc_hd__nor2_1
X_1238_ _0535_ _0562_ _0537_ VGND VGND VPWR VPWR _0564_ sky130_fd_sc_hd__a21oi_1
XFILLER_52_398 VGND VGND VPWR VPWR sky130_fd_sc_hd__fill_1
XFILLER_52_365 VGND VGND VPWR VPWR sky130_fd_sc_hd__decap_8
XFILLER_12_229 VGND VGND VPWR VPWR sky130_fd_sc_hd__decap_8
Xclkbuf_3_0__f_clk clknet_0_clk VGND VGND VPWR VPWR clknet_3_0__leaf_clk sky130_fd_sc_hd__clkbuf_16
XFILLER_28_362 VGND VGND VPWR VPWR sky130_fd_sc_hd__fill_2
XFILLER_18_73 VGND VGND VPWR VPWR sky130_fd_sc_hd__decap_4
XFILLER_34_83 VGND VGND VPWR VPWR sky130_fd_sc_hd__fill_1
XFILLER_11_251 VPWR VGND VPWR VGND sky130_ef_sc_hd__decap_12
XTAP_TAPCELL_ROW_21_290 VGND VPWR sky130_fd_sc_hd__tapvpwrvgnd_1
XFILLER_19_373 VPWR VGND VPWR VGND sky130_ef_sc_hd__decap_12
X_1023_ _0352_ _0351_ net74 net83 VGND VGND VPWR VPWR _0355_ sky130_fd_sc_hd__or4bb_4
XFILLER_34_365 VPWR VGND VPWR VGND sky130_ef_sc_hd__decap_12
X_0738_ net140 net107 _0113_ net110 VGND VGND VPWR VPWR _0013_ sky130_fd_sc_hd__o211a_1
XFILLER_30_19 VGND VGND VPWR VPWR sky130_fd_sc_hd__decap_8
X_0807_ net68 net16 _0144_ VGND VGND VPWR VPWR _0150_ sky130_fd_sc_hd__mux2_1
XPHY_EDGE_ROW_2_Right_2 VGND VGND VPWR VPWR sky130_fd_sc_hd__decap_3
XFILLER_40_324 VGND VGND VPWR VPWR sky130_fd_sc_hd__fill_1
XTAP_TAPCELL_ROW_35_382 VGND VPWR sky130_fd_sc_hd__tapvpwrvgnd_1
XTAP_TAPCELL_ROW_27_327 VGND VPWR sky130_fd_sc_hd__tapvpwrvgnd_1
XFILLER_63_405 VGND VGND VPWR VPWR sky130_fd_sc_hd__fill_2
Xhold50 net48 VGND VGND VPWR VPWR net166 sky130_fd_sc_hd__dlygate4sd3_1
Xhold61 core_out\[6\] VGND VGND VPWR VPWR net177 sky130_fd_sc_hd__dlygate4sd3_1
XFILLER_29_50 VGND VGND VPWR VPWR sky130_fd_sc_hd__fill_1
XFILLER_16_321 VPWR VGND VPWR VGND sky130_ef_sc_hd__decap_12
XFILLER_43_162 VGND VGND VPWR VPWR sky130_fd_sc_hd__decap_6
XFILLER_31_335 VGND VGND VPWR VPWR sky130_fd_sc_hd__fill_1
XFILLER_16_365 VPWR VGND VPWR VGND sky130_ef_sc_hd__decap_12
XFILLER_61_81 VPWR VGND VPWR VGND sky130_ef_sc_hd__decap_12
XFILLER_6_65 VPWR VGND VPWR VGND sky130_ef_sc_hd__decap_12
XFILLER_54_405 VGND VGND VPWR VPWR sky130_fd_sc_hd__fill_2
XTAP_TAPCELL_ROW_49_485 VGND VPWR sky130_fd_sc_hd__tapvpwrvgnd_1
XFILLER_34_184 VPWR VGND VPWR VGND sky130_ef_sc_hd__decap_12
XFILLER_34_173 VGND VGND VPWR VPWR sky130_fd_sc_hd__decap_3
X_1006_ _0257_ _0304_ _0302_ VGND VGND VPWR VPWR _0338_ sky130_fd_sc_hd__o21ai_1
XFILLER_26_118 VPWR VGND VPWR VGND sky130_ef_sc_hd__decap_12
XTAP_TAPCELL_ROW_24_308 VGND VPWR sky130_fd_sc_hd__tapvpwrvgnd_1
Xrebuffer15 net132 VGND VGND VPWR VPWR net131 sky130_fd_sc_hd__dlygate4sd1_1
XTAP_TAPCELL_ROW_32_363 VGND VPWR sky130_fd_sc_hd__tapvpwrvgnd_1
XFILLER_22_357 VGND VGND VPWR VPWR sky130_fd_sc_hd__decap_6
XFILLER_1_217 VGND VGND VPWR VPWR sky130_fd_sc_hd__decap_6
XFILLER_9_317 VPWR VGND VPWR VGND sky130_ef_sc_hd__decap_12
XFILLER_13_335 VGND VGND VPWR VPWR sky130_fd_sc_hd__fill_1
XFILLER_15_63 VGND VGND VPWR VPWR sky130_fd_sc_hd__decap_8
Xoutput40 net40 VGND VGND VPWR VPWR rdata[28] sky130_fd_sc_hd__buf_2
Xoutput51 net51 VGND VGND VPWR VPWR rdata[9] sky130_fd_sc_hd__buf_2
XFILLER_48_265 VPWR VGND VPWR VGND sky130_ef_sc_hd__decap_12
XFILLER_16_195 VGND VGND VPWR VPWR sky130_fd_sc_hd__fill_1
XFILLER_54_224 VPWR VGND VPWR VGND sky130_ef_sc_hd__decap_12
XFILLER_54_202 VPWR VGND VPWR VGND sky130_ef_sc_hd__decap_12
XFILLER_39_265 VGND VGND VPWR VPWR sky130_fd_sc_hd__fill_1
XTAP_TAPCELL_ROW_37_400 VGND VPWR sky130_fd_sc_hd__tapvpwrvgnd_1
XFILLER_36_29 VPWR VGND VPWR VGND sky130_ef_sc_hd__decap_12
XFILLER_22_176 VPWR VGND VPWR VGND sky130_ef_sc_hd__decap_12
XFILLER_6_309 VPWR VGND VPWR VGND sky130_ef_sc_hd__decap_12
XFILLER_26_73 VGND VGND VPWR VPWR sky130_fd_sc_hd__decap_8
XFILLER_42_83 VGND VGND VPWR VPWR sky130_fd_sc_hd__fill_1
XFILLER_9_103 VGND VGND VPWR VPWR sky130_fd_sc_hd__decap_8
XFILLER_9_125 VPWR VGND VPWR VGND sky130_ef_sc_hd__decap_12
XFILLER_9_169 VPWR VGND VPWR VGND sky130_ef_sc_hd__decap_12
XFILLER_13_121 VGND VGND VPWR VPWR sky130_fd_sc_hd__fill_2
X_1340_ core_out\[26\] net52 VGND VGND VPWR VPWR _0654_ sky130_fd_sc_hd__nand2_1
Xrebuffer6 net121 VGND VGND VPWR VPWR net122 sky130_fd_sc_hd__dlymetal6s2s_1
X_1271_ _0576_ _0583_ _0594_ net98 VGND VGND VPWR VPWR _0596_ sky130_fd_sc_hd__o31ai_1
XFILLER_3_55 VGND VGND VPWR VPWR sky130_fd_sc_hd__fill_1
X_0986_ _0315_ _0316_ _0301_ VGND VGND VPWR VPWR _0319_ sky130_fd_sc_hd__a21oi_1
Xfanout115 net116 VGND VGND VPWR VPWR net115 sky130_fd_sc_hd__dlymetal6s2s_1
XFILLER_59_349 VPWR VGND VPWR VGND sky130_ef_sc_hd__decap_12
Xfanout104 core_valid VGND VGND VPWR VPWR net104 sky130_fd_sc_hd__clkbuf_2
XFILLER_63_27 VPWR VGND VPWR VGND sky130_ef_sc_hd__decap_12
XTAP_TAPCELL_ROW_57_539 VGND VPWR sky130_fd_sc_hd__tapvpwrvgnd_1
XFILLER_27_279 VGND VGND VPWR VPWR sky130_fd_sc_hd__fill_1
XFILLER_42_249 VGND VGND VPWR VPWR sky130_fd_sc_hd__decap_3
XTAP_TAPCELL_ROW_40_417 VGND VPWR sky130_fd_sc_hd__tapvpwrvgnd_1
XFILLER_6_139 VGND VGND VPWR VPWR sky130_fd_sc_hd__fill_1
XFILLER_5_3 VPWR VGND VPWR VGND sky130_ef_sc_hd__decap_12
XFILLER_2_345 VPWR VGND VPWR VGND sky130_ef_sc_hd__decap_12
XFILLER_2_301 VGND VGND VPWR VPWR sky130_fd_sc_hd__decap_6
XFILLER_12_42 VPWR VGND VPWR VGND sky130_ef_sc_hd__decap_12
XFILLER_37_50 VGND VGND VPWR VPWR sky130_fd_sc_hd__decap_6
XTAP_TAPCELL_ROW_5_172 VGND VPWR sky130_fd_sc_hd__tapvpwrvgnd_1
XFILLER_2_389 VPWR VGND VPWR VGND sky130_ef_sc_hd__decap_12
XFILLER_37_83 VPWR VGND VPWR VGND sky130_ef_sc_hd__decap_12
XFILLER_18_235 VPWR VGND VPWR VGND sky130_ef_sc_hd__decap_12
X_0771_ net143 net105 net58 _0131_ net113 VGND VGND VPWR VPWR _0028_ sky130_fd_sc_hd__o221a_1
XFILLER_41_293 VGND VGND VPWR VPWR sky130_fd_sc_hd__fill_1
XFILLER_41_271 VGND VGND VPWR VPWR sky130_fd_sc_hd__decap_8
X_0840_ net97 net171 net110 _0177_ VGND VGND VPWR VPWR _0051_ sky130_fd_sc_hd__o211a_1
X_1323_ _0638_ _0639_ VGND VGND VPWR VPWR _0640_ sky130_fd_sc_hd__xnor2_1
XFILLER_38_3 VGND VGND VPWR VPWR sky130_fd_sc_hd__decap_4
XFILLER_5_161 VGND VGND VPWR VPWR sky130_fd_sc_hd__decap_6
XFILLER_49_393 VGND VGND VPWR VPWR sky130_fd_sc_hd__decap_8
XFILLER_49_382 VGND VGND VPWR VPWR sky130_fd_sc_hd__decap_8
X_1254_ _0492_ _0494_ _0579_ VGND VGND VPWR VPWR _0580_ sky130_fd_sc_hd__o21ai_4
X_1185_ _0504_ _0511_ VGND VGND VPWR VPWR _0513_ sky130_fd_sc_hd__xnor2_1
XTAP_TAPCELL_ROW_19_274 VGND VPWR sky130_fd_sc_hd__tapvpwrvgnd_1
XTAP_TAPCELL_ROW_62_575 VGND VPWR sky130_fd_sc_hd__tapvpwrvgnd_1
X_0969_ net72 net75 net85 net86 VGND VGND VPWR VPWR _0302_ sky130_fd_sc_hd__nand4_1
XFILLER_58_27 VGND VGND VPWR VPWR sky130_fd_sc_hd__fill_1
XFILLER_55_385 VGND VGND VPWR VPWR sky130_fd_sc_hd__decap_6
XTAP_TAPCELL_ROW_2_153 VGND VPWR sky130_fd_sc_hd__tapvpwrvgnd_1
XFILLER_2_197 VPWR VGND VPWR VGND sky130_ef_sc_hd__decap_12
XFILLER_2_153 VPWR VGND VPWR VGND sky130_ef_sc_hd__decap_12
XFILLER_64_81 VGND VGND VPWR VPWR sky130_fd_sc_hd__decap_3
XFILLER_46_396 VGND VGND VPWR VPWR sky130_fd_sc_hd__decap_6
XTAP_TAPCELL_ROW_16_255 VGND VPWR sky130_fd_sc_hd__tapvpwrvgnd_1
X_0823_ _0154_ _0161_ VGND VGND VPWR VPWR _0162_ sky130_fd_sc_hd__xnor2_1
X_0754_ core_out\[11\] net61 VGND VGND VPWR VPWR _0123_ sky130_fd_sc_hd__and2_1
XFILLER_9_98 VGND VGND VPWR VPWR sky130_fd_sc_hd__fill_1
X_1306_ _0625_ _0624_ net101 VGND VGND VPWR VPWR _0626_ sky130_fd_sc_hd__a21bo_1
XFILLER_44_29 VGND VGND VPWR VPWR sky130_fd_sc_hd__decap_8
X_1168_ net98 net176 net116 _0496_ VGND VGND VPWR VPWR _0060_ sky130_fd_sc_hd__o211a_1
X_1237_ _0534_ _0562_ VGND VGND VPWR VPWR _0563_ sky130_fd_sc_hd__xor2_1
X_1099_ _0424_ _0427_ VGND VGND VPWR VPWR _0429_ sky130_fd_sc_hd__xor2_1
XFILLER_55_160 VGND VGND VPWR VPWR sky130_fd_sc_hd__fill_1
XFILLER_11_241 VGND VGND VPWR VPWR sky130_fd_sc_hd__fill_1
XFILLER_7_223 VGND VGND VPWR VPWR sky130_fd_sc_hd__fill_1
XFILLER_11_263 VPWR VGND VPWR VGND sky130_ef_sc_hd__decap_12
XFILLER_59_81 VPWR VGND VPWR VGND sky130_ef_sc_hd__decap_12
XFILLER_34_377 VGND VGND VPWR VPWR sky130_fd_sc_hd__decap_8
XFILLER_34_322 VGND VGND VPWR VPWR sky130_fd_sc_hd__fill_1
XFILLER_19_385 VGND VGND VPWR VPWR sky130_fd_sc_hd__decap_6
X_1022_ _0351_ _0352_ net74 net83 VGND VGND VPWR VPWR _0354_ sky130_fd_sc_hd__a2bb2o_1
X_0737_ core_out\[4\] net62 _0112_ _0102_ VGND VGND VPWR VPWR _0113_ sky130_fd_sc_hd__a211o_1
X_0806_ net108 _0149_ VGND VGND VPWR VPWR _0045_ sky130_fd_sc_hd__and2_1
XFILLER_44_119 VPWR VGND VPWR VGND sky130_ef_sc_hd__decap_12
XPHY_EDGE_ROW_64_Left_129 VGND VGND VPWR VPWR sky130_fd_sc_hd__decap_3
XFILLER_52_185 VGND VGND VPWR VPWR sky130_fd_sc_hd__fill_1
XFILLER_52_141 VPWR VGND VPWR VGND sky130_ef_sc_hd__decap_12
XTAP_TAPCELL_ROW_35_383 VGND VPWR sky130_fd_sc_hd__tapvpwrvgnd_1
XTAP_TAPCELL_ROW_27_328 VGND VPWR sky130_fd_sc_hd__tapvpwrvgnd_1
Xhold40 net40 VGND VGND VPWR VPWR net156 sky130_fd_sc_hd__dlygate4sd3_1
Xhold51 core_out\[7\] VGND VGND VPWR VPWR net167 sky130_fd_sc_hd__dlygate4sd3_1
Xhold62 core_out\[19\] VGND VGND VPWR VPWR net178 sky130_fd_sc_hd__dlygate4sd3_1
XFILLER_45_83 VPWR VGND VPWR VGND sky130_ef_sc_hd__decap_12
XFILLER_16_300 VGND VGND VPWR VPWR sky130_fd_sc_hd__decap_8
XFILLER_16_333 VPWR VGND VPWR VGND sky130_ef_sc_hd__decap_12
XFILLER_61_93 VPWR VGND VPWR VGND sky130_ef_sc_hd__decap_12
XFILLER_43_185 VPWR VGND VPWR VGND sky130_ef_sc_hd__decap_12
XFILLER_16_377 VPWR VGND VPWR VGND sky130_ef_sc_hd__decap_12
XFILLER_6_77 VGND VGND VPWR VPWR sky130_fd_sc_hd__decap_6
XFILLER_3_281 VPWR VGND VPWR VGND sky130_ef_sc_hd__decap_12
XFILLER_20_3 VPWR VGND VPWR VGND sky130_ef_sc_hd__decap_12
XTAP_TAPCELL_ROW_49_486 VGND VPWR sky130_fd_sc_hd__tapvpwrvgnd_1
XFILLER_34_141 VPWR VGND VPWR VGND sky130_ef_sc_hd__decap_12
X_1005_ _0294_ _0297_ VGND VGND VPWR VPWR _0337_ sky130_fd_sc_hd__nor2_1
XFILLER_19_182 VPWR VGND VPWR VGND sky130_ef_sc_hd__decap_12
XTAP_TAPCELL_ROW_24_309 VGND VPWR sky130_fd_sc_hd__tapvpwrvgnd_1
XTAP_TAPCELL_ROW_32_364 VGND VPWR sky130_fd_sc_hd__tapvpwrvgnd_1
XFILLER_57_266 VGND VGND VPWR VPWR sky130_fd_sc_hd__decap_3
XFILLER_9_329 VGND VGND VPWR VPWR sky130_fd_sc_hd__decap_6
XFILLER_21_391 VGND VGND VPWR VPWR sky130_fd_sc_hd__fill_1
Xoutput41 net41 VGND VGND VPWR VPWR rdata[29] sky130_fd_sc_hd__buf_2
Xoutput30 net30 VGND VGND VPWR VPWR rdata[19] sky130_fd_sc_hd__buf_2
XFILLER_48_277 VPWR VGND VPWR VGND sky130_ef_sc_hd__decap_12
XFILLER_16_141 VPWR VGND VPWR VGND sky130_ef_sc_hd__decap_12
XFILLER_16_163 VPWR VGND VPWR VGND sky130_ef_sc_hd__decap_12
.ends
